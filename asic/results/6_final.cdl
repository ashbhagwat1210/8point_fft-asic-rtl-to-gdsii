* CDL Netlist generated by OpenROAD

*.BUSDELIMITER [

.SUBCKT fft_8point_top clk in_flat[0] in_flat[100] in_flat[101]
+ in_flat[102] in_flat[103] in_flat[104] in_flat[105] in_flat[106]
+ in_flat[107] in_flat[108] in_flat[109] in_flat[10] in_flat[110]
+ in_flat[111] in_flat[112] in_flat[113] in_flat[114] in_flat[115]
+ in_flat[116] in_flat[117] in_flat[118] in_flat[119] in_flat[11]
+ in_flat[120] in_flat[121] in_flat[122] in_flat[123] in_flat[124]
+ in_flat[125] in_flat[126] in_flat[127] in_flat[12] in_flat[13]
+ in_flat[14] in_flat[15] in_flat[16] in_flat[17] in_flat[18]
+ in_flat[19] in_flat[1] in_flat[20] in_flat[21] in_flat[22]
+ in_flat[23] in_flat[24] in_flat[25] in_flat[26] in_flat[27]
+ in_flat[28] in_flat[29] in_flat[2] in_flat[30] in_flat[31]
+ in_flat[32] in_flat[33] in_flat[34] in_flat[35] in_flat[36]
+ in_flat[37] in_flat[38] in_flat[39] in_flat[3] in_flat[40]
+ in_flat[41] in_flat[42] in_flat[43] in_flat[44] in_flat[45]
+ in_flat[46] in_flat[47] in_flat[48] in_flat[49] in_flat[4]
+ in_flat[50] in_flat[51] in_flat[52] in_flat[53] in_flat[54]
+ in_flat[55] in_flat[56] in_flat[57] in_flat[58] in_flat[59]
+ in_flat[5] in_flat[60] in_flat[61] in_flat[62] in_flat[63]
+ in_flat[64] in_flat[65] in_flat[66] in_flat[67] in_flat[68]
+ in_flat[69] in_flat[6] in_flat[70] in_flat[71] in_flat[72]
+ in_flat[73] in_flat[74] in_flat[75] in_flat[76] in_flat[77]
+ in_flat[78] in_flat[79] in_flat[7] in_flat[80] in_flat[81]
+ in_flat[82] in_flat[83] in_flat[84] in_flat[85] in_flat[86]
+ in_flat[87] in_flat[88] in_flat[89] in_flat[8] in_flat[90]
+ in_flat[91] in_flat[92] in_flat[93] in_flat[94] in_flat[95]
+ in_flat[96] in_flat[97] in_flat[98] in_flat[99] in_flat[9]
+ in_valid out_flat[0] out_flat[100] out_flat[101] out_flat[102]
+ out_flat[103] out_flat[104] out_flat[105] out_flat[106] out_flat[107]
+ out_flat[108] out_flat[109] out_flat[10] out_flat[110] out_flat[111]
+ out_flat[112] out_flat[113] out_flat[114] out_flat[115] out_flat[116]
+ out_flat[117] out_flat[118] out_flat[119] out_flat[11] out_flat[120]
+ out_flat[121] out_flat[122] out_flat[123] out_flat[124] out_flat[125]
+ out_flat[126] out_flat[127] out_flat[128] out_flat[129] out_flat[12]
+ out_flat[130] out_flat[131] out_flat[132] out_flat[133] out_flat[134]
+ out_flat[135] out_flat[136] out_flat[137] out_flat[138] out_flat[139]
+ out_flat[13] out_flat[140] out_flat[141] out_flat[142] out_flat[143]
+ out_flat[144] out_flat[145] out_flat[146] out_flat[147] out_flat[148]
+ out_flat[149] out_flat[14] out_flat[150] out_flat[151] out_flat[152]
+ out_flat[153] out_flat[154] out_flat[155] out_flat[156] out_flat[157]
+ out_flat[158] out_flat[159] out_flat[15] out_flat[160] out_flat[161]
+ out_flat[162] out_flat[163] out_flat[164] out_flat[165] out_flat[166]
+ out_flat[167] out_flat[168] out_flat[169] out_flat[16] out_flat[170]
+ out_flat[171] out_flat[172] out_flat[173] out_flat[174] out_flat[175]
+ out_flat[176] out_flat[177] out_flat[178] out_flat[179] out_flat[17]
+ out_flat[180] out_flat[181] out_flat[182] out_flat[183] out_flat[184]
+ out_flat[185] out_flat[186] out_flat[187] out_flat[188] out_flat[189]
+ out_flat[18] out_flat[190] out_flat[191] out_flat[192] out_flat[193]
+ out_flat[194] out_flat[195] out_flat[196] out_flat[197] out_flat[198]
+ out_flat[199] out_flat[19] out_flat[1] out_flat[200] out_flat[201]
+ out_flat[202] out_flat[203] out_flat[204] out_flat[205] out_flat[206]
+ out_flat[207] out_flat[208] out_flat[209] out_flat[20] out_flat[210]
+ out_flat[211] out_flat[212] out_flat[213] out_flat[214] out_flat[215]
+ out_flat[216] out_flat[217] out_flat[218] out_flat[219] out_flat[21]
+ out_flat[220] out_flat[221] out_flat[222] out_flat[223] out_flat[224]
+ out_flat[225] out_flat[226] out_flat[227] out_flat[228] out_flat[229]
+ out_flat[22] out_flat[230] out_flat[231] out_flat[232] out_flat[233]
+ out_flat[234] out_flat[235] out_flat[236] out_flat[237] out_flat[238]
+ out_flat[239] out_flat[23] out_flat[240] out_flat[241] out_flat[242]
+ out_flat[243] out_flat[244] out_flat[245] out_flat[246] out_flat[247]
+ out_flat[248] out_flat[249] out_flat[24] out_flat[250] out_flat[251]
+ out_flat[252] out_flat[253] out_flat[254] out_flat[255] out_flat[25]
+ out_flat[26] out_flat[27] out_flat[28] out_flat[29] out_flat[2]
+ out_flat[30] out_flat[31] out_flat[32] out_flat[33] out_flat[34]
+ out_flat[35] out_flat[36] out_flat[37] out_flat[38] out_flat[39]
+ out_flat[3] out_flat[40] out_flat[41] out_flat[42] out_flat[43]
+ out_flat[44] out_flat[45] out_flat[46] out_flat[47] out_flat[48]
+ out_flat[49] out_flat[4] out_flat[50] out_flat[51] out_flat[52]
+ out_flat[53] out_flat[54] out_flat[55] out_flat[56] out_flat[57]
+ out_flat[58] out_flat[59] out_flat[5] out_flat[60] out_flat[61]
+ out_flat[62] out_flat[63] out_flat[64] out_flat[65] out_flat[66]
+ out_flat[67] out_flat[68] out_flat[69] out_flat[6] out_flat[70]
+ out_flat[71] out_flat[72] out_flat[73] out_flat[74] out_flat[75]
+ out_flat[76] out_flat[77] out_flat[78] out_flat[79] out_flat[7]
+ out_flat[80] out_flat[81] out_flat[82] out_flat[83] out_flat[84]
+ out_flat[85] out_flat[86] out_flat[87] out_flat[88] out_flat[89]
+ out_flat[8] out_flat[90] out_flat[91] out_flat[92] out_flat[93]
+ out_flat[94] out_flat[95] out_flat[96] out_flat[97] out_flat[98]
+ out_flat[99] out_flat[9] out_valid rst_n VSS VDD
X_06051_ stage3_in_r\[48\] VSS VSS VDD VDD _01126_ sky130_fd_sc_hd__inv_1
Xinput142 in_flat[83] VSS VSS VDD VDD net141 sky130_fd_sc_hd__clkdlybuf4s50_1
X_06053_ net432 VSS VSS VDD VDD _00044_ sky130_fd_sc_hd__clkinv_1
Xinput141 in_flat[82] VSS VSS VDD VDD net140 sky130_fd_sc_hd__clkdlybuf4s50_1
X_06055_ _00934_ net432 VSS VSS VDD VDD _00006_ sky130_fd_sc_hd__xnor2_1
Xinput140 in_flat[81] VSS VSS VDD VDD net139 sky130_fd_sc_hd__clkdlybuf4s50_1
X_06057_ _01266_ VSS VSS VDD VDD _02890_ sky130_fd_sc_hd__inv_1
X_06058_ _01281_ _01273_ _01272_ VSS VSS VDD VDD _02891_ sky130_fd_sc_hd__a21o_1
X_06059_ _01269_ _02891_ _01268_ VSS VSS VDD VDD _02892_ sky130_fd_sc_hd__a21oi_1
X_06060_ _01250_ _01252_ _01258_ _01249_ VSS VSS VDD VDD _02893_
+ sky130_fd_sc_hd__a211oi_1
X_06061_ _01265_ VSS VSS VDD VDD _02894_ sky130_fd_sc_hd__inv_1
X_06062_ _02890_ _02892_ _02893_ _02894_ VSS VSS VDD VDD _02895_
+ sky130_fd_sc_hd__o211a_1
X_06063_ _01259_ _01258_ _01253_ VSS VSS VDD VDD _02896_ sky130_fd_sc_hd__o21ai_0
X_06064_ _01252_ _02896_ VSS VSS VDD VDD _02897_ sky130_fd_sc_hd__nand2b_1
X_06065_ _01250_ _02897_ _01249_ VSS VSS VDD VDD _02898_ sky130_fd_sc_hd__a21oi_1
X_06066_ _01232_ _01242_ VSS VSS VDD VDD _02899_ sky130_fd_sc_hd__nand2_1
X_06067_ _01232_ _01241_ _01231_ VSS VSS VDD VDD _02900_ sky130_fd_sc_hd__a21oi_1
X_06068_ _02895_ _02898_ _02899_ _02900_ VSS VSS VDD VDD _02901_
+ sky130_fd_sc_hd__o31ai_2
X_06069_ _01238_ _01227_ _01237_ VSS VSS VDD VDD _02902_ sky130_fd_sc_hd__a21o_1
X_06070_ _01238_ _01228_ _02901_ _02902_ VSS VSS VDD VDD _02903_
+ sky130_fd_sc_hd__a31oi_1
X_06071_ _01218_ _02903_ VSS VSS VDD VDD _01595_ sky130_fd_sc_hd__xnor2_1
X_06072_ _01595_ VSS VSS VDD VDD _01598_ sky130_fd_sc_hd__inv_1
Xinput139 in_flat[80] VSS VSS VDD VDD net138 sky130_fd_sc_hd__clkdlybuf4s50_1
X_06074_ _01183_ _01188_ _01182_ VSS VSS VDD VDD _02905_ sky130_fd_sc_hd__a21o_1
X_06075_ _01195_ VSS VSS VDD VDD _02906_ sky130_fd_sc_hd__inv_1
X_06076_ _00266_ _01199_ VSS VSS VDD VDD _02907_ sky130_fd_sc_hd__nor2b_1
X_06077_ _01198_ _02907_ _01196_ VSS VSS VDD VDD _02908_ sky130_fd_sc_hd__o21ai_1
X_06078_ _01183_ _01189_ VSS VSS VDD VDD _02909_ sky130_fd_sc_hd__nand2_1
X_06079_ _02906_ _02908_ _02909_ VSS VSS VDD VDD _02910_ sky130_fd_sc_hd__a21oi_1
X_06080_ _01173_ _01180_ _02905_ _02910_ VSS VSS VDD VDD _02911_
+ sky130_fd_sc_hd__nor4_2
X_06081_ _01181_ _01180_ _01174_ VSS VSS VDD VDD _02912_ sky130_fd_sc_hd__o21ai_0
X_06082_ _01173_ _02912_ VSS VSS VDD VDD _02913_ sky130_fd_sc_hd__nand2b_1
X_06083_ _02911_ _02913_ VSS VSS VDD VDD _02914_ sky130_fd_sc_hd__nand2b_4
X_06084_ _01164_ _01159_ VSS VSS VDD VDD _02915_ sky130_fd_sc_hd__nand2_1
X_06085_ _01159_ _01163_ _01158_ VSS VSS VDD VDD _02916_ sky130_fd_sc_hd__a21oi_1
X_06086_ _02914_ _02915_ _02916_ VSS VSS VDD VDD _02917_ sky130_fd_sc_hd__o21ai_0
X_06087_ _01170_ _02917_ VSS VSS VDD VDD _01275_ sky130_fd_sc_hd__xor2_1
X_06088_ _01241_ VSS VSS VDD VDD _02918_ sky130_fd_sc_hd__inv_1
X_06089_ _01253_ _01252_ _01250_ VSS VSS VDD VDD _02919_ sky130_fd_sc_hd__o21a_1
X_06090_ _00271_ _01269_ VSS VSS VDD VDD _02920_ sky130_fd_sc_hd__nor2b_1
X_06091_ _01268_ _02920_ _01266_ VSS VSS VDD VDD _02921_ sky130_fd_sc_hd__o21ai_1
X_06092_ _02894_ _02921_ _01259_ VSS VSS VDD VDD _02922_ sky130_fd_sc_hd__a21boi_1
X_06093_ _01249_ _01252_ _01258_ VSS VSS VDD VDD _02923_ sky130_fd_sc_hd__or3_1
X_06094_ _01249_ _02919_ _02922_ _02923_ _01242_ VSS VSS VDD
+ VDD _02924_ sky130_fd_sc_hd__o221ai_2
X_06095_ _01232_ VSS VSS VDD VDD _02925_ sky130_fd_sc_hd__inv_1
X_06096_ _02918_ _02924_ _02925_ VSS VSS VDD VDD _02926_ sky130_fd_sc_hd__a21oi_1
X_06097_ _01231_ _02926_ _01228_ VSS VSS VDD VDD _02927_ sky130_fd_sc_hd__o21ai_0
X_06098_ _01227_ _02927_ VSS VSS VDD VDD _02928_ sky130_fd_sc_hd__nor2b_1
X_06099_ _01238_ _02928_ VSS VSS VDD VDD _01274_ sky130_fd_sc_hd__xnor2_1
X_06100_ _01274_ VSS VSS VDD VDD _01278_ sky130_fd_sc_hd__inv_1
X_06101_ _01164_ _01174_ VSS VSS VDD VDD _02929_ sky130_fd_sc_hd__and2_1
X_06102_ _01181_ _01182_ _01180_ VSS VSS VDD VDD _02930_ sky130_fd_sc_hd__a21o_1
X_06103_ _01159_ _02929_ _02930_ VSS VSS VDD VDD _02931_ sky130_fd_sc_hd__and3_1
X_06104_ _01189_ _01196_ VSS VSS VDD VDD _02932_ sky130_fd_sc_hd__and2_1
X_06105_ _01189_ _01195_ _01198_ _02932_ _01188_ VSS VSS VDD
+ VDD _02933_ sky130_fd_sc_hd__a221oi_2
X_06106_ _01280_ _01203_ _01202_ VSS VSS VDD VDD _02934_ sky130_fd_sc_hd__a21o_1
X_06107_ _01199_ _02932_ _02934_ VSS VSS VDD VDD _02935_ sky130_fd_sc_hd__nand3_1
X_06108_ _01183_ _01159_ _01181_ _02929_ VSS VSS VDD VDD _02936_
+ sky130_fd_sc_hd__nand4_1
X_06109_ _02933_ _02935_ _02936_ VSS VSS VDD VDD _02937_ sky130_fd_sc_hd__a21oi_2
X_06110_ _02931_ _02937_ VSS VSS VDD VDD _02938_ sky130_fd_sc_hd__nor2_1
X_06111_ _02933_ _02935_ VSS VSS VDD VDD _02939_ sky130_fd_sc_hd__nand2_1
X_06112_ _01164_ _01173_ _01163_ VSS VSS VDD VDD _02940_ sky130_fd_sc_hd__a21oi_1
X_06113_ _02930_ _02940_ VSS VSS VDD VDD _02941_ sky130_fd_sc_hd__nand2b_1
X_06114_ _01183_ _01181_ _02941_ _01159_ VSS VSS VDD VDD _02942_
+ sky130_fd_sc_hd__a211o_1
X_06115_ _01159_ _02929_ VSS VSS VDD VDD _02943_ sky130_fd_sc_hd__nor2_1
X_06116_ _02940_ _01159_ VSS VSS VDD VDD _02944_ sky130_fd_sc_hd__nor2b_1
X_06117_ _02940_ _02943_ _02944_ VSS VSS VDD VDD _02945_ sky130_fd_sc_hd__a21oi_1
X_06118_ _01159_ _02939_ _02941_ _02942_ _02945_ VSS VSS VDD
+ VDD _02946_ sky130_fd_sc_hd__o311a_1
X_06119_ _02938_ _02946_ VSS VSS VDD VDD _01601_ sky130_fd_sc_hd__and2_1
X_06120_ _01228_ _02901_ VSS VSS VDD VDD _01600_ sky130_fd_sc_hd__xor2_2
X_06121_ _01600_ VSS VSS VDD VDD _01604_ sky130_fd_sc_hd__inv_1
X_06122_ _02918_ _02924_ VSS VSS VDD VDD _02947_ sky130_fd_sc_hd__and2_1
X_06123_ _01232_ _02947_ VSS VSS VDD VDD _01606_ sky130_fd_sc_hd__xnor2_1
X_06124_ _01606_ VSS VSS VDD VDD _01610_ sky130_fd_sc_hd__inv_1
X_06125_ _02895_ _02898_ VSS VSS VDD VDD _02948_ sky130_fd_sc_hd__nor2_1
X_06126_ _01242_ _02948_ VSS VSS VDD VDD _01612_ sky130_fd_sc_hd__xor2_1
X_06127_ _01612_ VSS VSS VDD VDD _01616_ sky130_fd_sc_hd__inv_1
X_06128_ _01258_ _02922_ _01253_ VSS VSS VDD VDD _02949_ sky130_fd_sc_hd__o21ai_0
X_06129_ _01252_ _02949_ VSS VSS VDD VDD _02950_ sky130_fd_sc_hd__nand2b_1
X_06130_ _01250_ _02950_ VSS VSS VDD VDD _01618_ sky130_fd_sc_hd__xor2_1
X_06131_ _01618_ VSS VSS VDD VDD _01622_ sky130_fd_sc_hd__inv_1
X_06132_ _02890_ _02892_ _02894_ VSS VSS VDD VDD _02951_ sky130_fd_sc_hd__o21ai_0
X_06133_ _01259_ _02951_ _01258_ VSS VSS VDD VDD _02952_ sky130_fd_sc_hd__a21oi_1
X_06134_ _01253_ _02952_ VSS VSS VDD VDD _01624_ sky130_fd_sc_hd__xnor2_1
X_06135_ _01624_ VSS VSS VDD VDD _01628_ sky130_fd_sc_hd__inv_1
X_06136_ _02894_ _02921_ VSS VSS VDD VDD _02953_ sky130_fd_sc_hd__nand2_1
X_06137_ _01259_ _02953_ VSS VSS VDD VDD _02954_ sky130_fd_sc_hd__nor2_1
X_06138_ _02922_ _02954_ VSS VSS VDD VDD _01630_ sky130_fd_sc_hd__nor2_1
X_06139_ _01630_ VSS VSS VDD VDD _01634_ sky130_fd_sc_hd__inv_1
X_06140_ _01266_ _02892_ VSS VSS VDD VDD _01636_ sky130_fd_sc_hd__xnor2_1
X_06141_ _01636_ VSS VSS VDD VDD _01640_ sky130_fd_sc_hd__inv_1
X_06142_ _00271_ _01269_ VSS VSS VDD VDD _01642_ sky130_fd_sc_hd__xnor2_1
X_06143_ _01642_ VSS VSS VDD VDD _01646_ sky130_fd_sc_hd__inv_1
X_06144_ _01605_ VSS VSS VDD VDD _02955_ sky130_fd_sc_hd__inv_1
X_06145_ _01601_ _01600_ VSS VSS VDD VDD _02956_ sky130_fd_sc_hd__xor2_1
X_06146_ _01629_ _01627_ VSS VSS VDD VDD _02957_ sky130_fd_sc_hd__nor2b_1
X_06147_ _01615_ VSS VSS VDD VDD _02958_ sky130_fd_sc_hd__inv_1
X_06148_ _02958_ _01623_ _01617_ VSS VSS VDD VDD _02959_ sky130_fd_sc_hd__a21oi_1
X_06149_ _01609_ _02959_ VSS VSS VDD VDD _02960_ sky130_fd_sc_hd__nor2_1
X_06150_ _01605_ _01611_ _02960_ VSS VSS VDD VDD _02961_ sky130_fd_sc_hd__nor3_1
X_06151_ _01609_ _01615_ _01621_ _02957_ _02961_ VSS VSS VDD
+ VDD _02962_ sky130_fd_sc_hd__o41ai_2
X_06152_ _02962_ VSS VSS VDD VDD _02963_ sky130_fd_sc_hd__inv_1
X_06153_ _01645_ VSS VSS VDD VDD _02964_ sky130_fd_sc_hd__inv_1
X_06154_ _01666_ VSS VSS VDD VDD _02965_ sky130_fd_sc_hd__inv_1
X_06155_ net445 stage3_in_r\[0\] VSS VSS VDD VDD _02966_ sky130_fd_sc_hd__nand2b_1
X_06156_ _02965_ _02966_ _01668_ VSS VSS VDD VDD _02967_ sky130_fd_sc_hd__a21oi_1
X_06157_ _01662_ _02967_ _01664_ VSS VSS VDD VDD _02968_ sky130_fd_sc_hd__o21bai_1
X_06158_ _01651_ _01654_ _01658_ VSS VSS VDD VDD _02969_ sky130_fd_sc_hd__nor3_1
X_06159_ _01654_ VSS VSS VDD VDD _02970_ sky130_fd_sc_hd__inv_1
X_06160_ _02970_ _01660_ _01656_ VSS VSS VDD VDD _02971_ sky130_fd_sc_hd__a21oi_1
X_06161_ _01651_ _02971_ VSS VSS VDD VDD _02972_ sky130_fd_sc_hd__nor2_1
X_06162_ _02968_ _02969_ _02972_ _01652_ VSS VSS VDD VDD _02973_
+ sky130_fd_sc_hd__a211o_1
X_06163_ _02964_ _02973_ _01647_ VSS VSS VDD VDD _02974_ sky130_fd_sc_hd__a21oi_1
X_06164_ _01633_ _01641_ VSS VSS VDD VDD _02975_ sky130_fd_sc_hd__nor2b_1
X_06165_ _01629_ _01635_ _02975_ VSS VSS VDD VDD _02976_ sky130_fd_sc_hd__nor3_1
X_06166_ _01633_ _01639_ _02974_ _02976_ _02961_ VSS VSS VDD
+ VDD _02977_ sky130_fd_sc_hd__o311a_1
X_06167_ _02955_ _02956_ _02963_ _01277_ _02977_ VSS VSS VDD
+ VDD _02978_ sky130_fd_sc_hd__a2111oi_2
X_06168_ _01279_ _02978_ VSS VSS VDD VDD _02979_ sky130_fd_sc_hd__nor2_1
X_06169_ _02931_ _02944_ VSS VSS VDD VDD _02980_ sky130_fd_sc_hd__nor2_1
X_06170_ _01147_ VSS VSS VDD VDD _02981_ sky130_fd_sc_hd__inv_1
X_06171_ _02981_ _01158_ _01169_ VSS VSS VDD VDD _02982_ sky130_fd_sc_hd__nor3_1
X_06172_ _02937_ _02980_ _02982_ VSS VSS VDD VDD _02983_ sky130_fd_sc_hd__nand3b_1
X_06173_ _01147_ _01170_ VSS VSS VDD VDD _02984_ sky130_fd_sc_hd__nor2b_1
X_06174_ _02931_ _02937_ _02944_ _02984_ VSS VSS VDD VDD _02985_
+ sky130_fd_sc_hd__o31ai_1
X_06175_ _01170_ _02981_ _01169_ VSS VSS VDD VDD _02986_ sky130_fd_sc_hd__nor3_1
X_06176_ _02981_ _01169_ _02984_ _01158_ _02986_ VSS VSS VDD
+ VDD _02987_ sky130_fd_sc_hd__a221oi_1
X_06177_ _02983_ _02985_ _02987_ VSS VSS VDD VDD _01594_ sky130_fd_sc_hd__nand3_1
X_06178_ _01595_ _01594_ VSS VSS VDD VDD _02988_ sky130_fd_sc_hd__xor2_1
X_06179_ _02979_ _02988_ VSS VSS VDD VDD _01118_ sky130_fd_sc_hd__xor2_1
X_06180_ _01118_ VSS VSS VDD VDD _01121_ sky130_fd_sc_hd__inv_1
X_06181_ _01492_ _01493_ VSS VSS VDD VDD _01285_ sky130_fd_sc_hd__or2_2
X_06182_ _01285_ VSS VSS VDD VDD _01335_ sky130_fd_sc_hd__inv_1
X_06183_ _00288_ VSS VSS VDD VDD _00285_ sky130_fd_sc_hd__inv_1
Xinput138 in_flat[7] VSS VSS VDD VDD net137 sky130_fd_sc_hd__clkdlybuf4s50_1
Xinput137 in_flat[79] VSS VSS VDD VDD net136 sky130_fd_sc_hd__clkdlybuf4s50_1
X_06186_ _01523_ net459 VSS VSS VDD VDD _00292_ sky130_fd_sc_hd__xor2_1
X_06187_ _00304_ VSS VSS VDD VDD _00301_ sky130_fd_sc_hd__inv_1
X_06188_ _01218_ _02902_ _01217_ VSS VSS VDD VDD _02991_ sky130_fd_sc_hd__a21oi_1
Xinput136 in_flat[78] VSS VSS VDD VDD net135 sky130_fd_sc_hd__clkdlybuf4s50_1
X_06190_ _01297_ _01231_ VSS VSS VDD VDD _02993_ sky130_fd_sc_hd__nor2_1
X_06191_ _02991_ _02993_ VSS VSS VDD VDD _02994_ sky130_fd_sc_hd__nand2_1
X_06192_ _01238_ _01218_ _01228_ VSS VSS VDD VDD _02995_ sky130_fd_sc_hd__and3_4
X_06193_ _01297_ VSS VSS VDD VDD _02996_ sky130_fd_sc_hd__inv_1
X_06194_ _01297_ _02995_ VSS VSS VDD VDD _02997_ sky130_fd_sc_hd__nor2_1
X_06195_ _02991_ _02997_ VSS VSS VDD VDD _02998_ sky130_fd_sc_hd__nand2_1
X_06196_ _02996_ _02991_ _02998_ VSS VSS VDD VDD _02999_ sky130_fd_sc_hd__o21ai_0
X_06197_ _01297_ _01231_ _02995_ _02999_ VSS VSS VDD VDD _03000_
+ sky130_fd_sc_hd__a31oi_1
X_06198_ _01297_ _02995_ VSS VSS VDD VDD _03001_ sky130_fd_sc_hd__nand2_1
X_06199_ _02918_ _02924_ _03001_ _02925_ VSS VSS VDD VDD _03002_
+ sky130_fd_sc_hd__a211o_1
X_06200_ _02926_ _02994_ _03000_ _03002_ VSS VSS VDD VDD _01673_
+ sky130_fd_sc_hd__o211ai_1
X_06201_ _01279_ _02978_ _02988_ VSS VSS VDD VDD _03003_ sky130_fd_sc_hd__o21ba_2
X_06202_ _01599_ _03003_ VSS VSS VDD VDD _03004_ sky130_fd_sc_hd__nor2_1
Xinput135 in_flat[77] VSS VSS VDD VDD net134 sky130_fd_sc_hd__clkdlybuf4s50_1
X_06204_ _01147_ _01169_ _01146_ VSS VSS VDD VDD _03006_ sky130_fd_sc_hd__a21oi_2
X_06205_ _02916_ _03006_ VSS VSS VDD VDD _03007_ sky130_fd_sc_hd__nand2_1
X_06206_ _01290_ _03007_ VSS VSS VDD VDD _03008_ sky130_fd_sc_hd__nor2_1
X_06207_ _03006_ _01290_ VSS VSS VDD VDD _03009_ sky130_fd_sc_hd__nor2b_1
X_06208_ _01170_ _01147_ _01290_ VSS VSS VDD VDD _03010_ sky130_fd_sc_hd__a21oi_1
X_06209_ _01170_ _01147_ _01290_ VSS VSS VDD VDD _03011_ sky130_fd_sc_hd__nand3_1
X_06210_ _02916_ _03011_ VSS VSS VDD VDD _03012_ sky130_fd_sc_hd__nor2_1
X_06211_ _01290_ _03007_ _02915_ VSS VSS VDD VDD _03013_ sky130_fd_sc_hd__nor3b_1
X_06212_ _03006_ _03010_ _03012_ _03013_ VSS VSS VDD VDD _03014_
+ sky130_fd_sc_hd__a211o_1
X_06213_ _02915_ _03011_ VSS VSS VDD VDD _03015_ sky130_fd_sc_hd__nor2_1
X_06214_ _02913_ _03015_ VSS VSS VDD VDD _03016_ sky130_fd_sc_hd__nand2_1
X_06215_ net425 _03016_ VSS VSS VDD VDD _03017_ sky130_fd_sc_hd__nor2_1
X_06216_ _02914_ _03008_ _03009_ _03014_ _03017_ VSS VSS VDD
+ VDD _01669_ sky130_fd_sc_hd__a2111oi_4
X_06217_ _01673_ _01669_ VSS VSS VDD VDD _03018_ sky130_fd_sc_hd__xnor2_1
X_06218_ _03004_ _03018_ VSS VSS VDD VDD _01544_ sky130_fd_sc_hd__xor2_1
X_06219_ _01544_ VSS VSS VDD VDD _01547_ sky130_fd_sc_hd__inv_1
X_06220_ _00010_ VSS VSS VDD VDD _00046_ sky130_fd_sc_hd__inv_1
X_06221_ _00311_ _00010_ VSS VSS VDD VDD _03019_ sky130_fd_sc_hd__xor2_1
X_06222_ net431 _03019_ VSS VSS VDD VDD _01300_ sky130_fd_sc_hd__xnor2_1
X_06223_ _00319_ VSS VSS VDD VDD _00316_ sky130_fd_sc_hd__inv_1
X_06224_ _01522_ _01524_ VSS VSS VDD VDD _01313_ sky130_fd_sc_hd__or2_2
X_06225_ _01313_ VSS VSS VDD VDD _01367_ sky130_fd_sc_hd__inv_1
X_06226_ _00331_ VSS VSS VDD VDD _00328_ sky130_fd_sc_hd__inv_1
X_06227_ _01217_ _01296_ VSS VSS VDD VDD _03020_ sky130_fd_sc_hd__nor2_1
X_06228_ _01218_ _01217_ VSS VSS VDD VDD _03021_ sky130_fd_sc_hd__nor2_1
X_06229_ _02996_ _03021_ VSS VSS VDD VDD _03022_ sky130_fd_sc_hd__nor2_1
X_06230_ _01296_ _03022_ _01318_ VSS VSS VDD VDD _03023_ sky130_fd_sc_hd__o21ai_0
X_06231_ _01218_ _01297_ VSS VSS VDD VDD _03024_ sky130_fd_sc_hd__nand2_1
X_06232_ _01297_ _01217_ _01296_ VSS VSS VDD VDD _03025_ sky130_fd_sc_hd__a21oi_1
X_06233_ _01318_ VSS VSS VDD VDD _03026_ sky130_fd_sc_hd__inv_1
X_06234_ _02903_ _03024_ _03025_ _03026_ VSS VSS VDD VDD _03027_
+ sky130_fd_sc_hd__o211ai_1
X_06235_ _01318_ _02903_ _03020_ _03023_ _03027_ VSS VSS VDD
+ VDD _01676_ sky130_fd_sc_hd__a32o_1
X_06236_ _01676_ VSS VSS VDD VDD _01679_ sky130_fd_sc_hd__inv_1
X_06237_ _01290_ _01146_ _01289_ VSS VSS VDD VDD _03028_ sky130_fd_sc_hd__a21o_1
X_06238_ _01158_ _01169_ _02937_ _02980_ VSS VSS VDD VDD _03029_
+ sky130_fd_sc_hd__or4b_1
X_06239_ _01290_ _01146_ _01289_ VSS VSS VDD VDD _03030_ sky130_fd_sc_hd__a21oi_1
X_06240_ _01170_ _01169_ _01290_ _01147_ VSS VSS VDD VDD _03031_
+ sky130_fd_sc_hd__o211ai_1
X_06241_ _03030_ _03031_ VSS VSS VDD VDD _03032_ sky130_fd_sc_hd__nand2_1
X_06242_ _03028_ _03029_ _03032_ _01308_ VSS VSS VDD VDD _03033_
+ sky130_fd_sc_hd__o211ai_1
X_06243_ _01158_ _01169_ _02937_ _02980_ VSS VSS VDD VDD _03034_
+ sky130_fd_sc_hd__nor4b_2
X_06244_ _01308_ VSS VSS VDD VDD _03035_ sky130_fd_sc_hd__inv_1
X_06245_ _03031_ _03034_ _03035_ _03030_ VSS VSS VDD VDD _03036_
+ sky130_fd_sc_hd__o211ai_1
X_06246_ _03033_ _03036_ VSS VSS VDD VDD _01675_ sky130_fd_sc_hd__and2_1
X_06247_ _01676_ _01675_ VSS VSS VDD VDD _03037_ sky130_fd_sc_hd__xnor2_1
X_06248_ _03004_ _03018_ VSS VSS VDD VDD _03038_ sky130_fd_sc_hd__nor2_1
X_06249_ _01674_ _03038_ VSS VSS VDD VDD _03039_ sky130_fd_sc_hd__nor2_1
X_06250_ _03037_ _03039_ VSS VSS VDD VDD _01549_ sky130_fd_sc_hd__xnor2_2
X_06251_ _01549_ VSS VSS VDD VDD _01552_ sky130_fd_sc_hd__inv_1
X_06252_ net458 VSS VSS VDD VDD _03040_ sky130_fd_sc_hd__inv_1
X_06253_ _01277_ VSS VSS VDD VDD _03041_ sky130_fd_sc_hd__inv_1
X_06254_ _02955_ _02956_ _02977_ _02963_ VSS VSS VDD VDD _03042_
+ sky130_fd_sc_hd__a211oi_1
X_06255_ _03041_ _03042_ VSS VSS VDD VDD _03043_ sky130_fd_sc_hd__xnor2_1
X_06256_ _03040_ _03043_ VSS VSS VDD VDD _01124_ sky130_fd_sc_hd__nor2_1
X_06257_ net430 _03019_ _00276_ VSS VSS VDD VDD _00337_ sky130_fd_sc_hd__mux2_2
X_06258_ _00341_ VSS VSS VDD VDD _00338_ sky130_fd_sc_hd__inv_1
X_06259_ _00145_ VSS VSS VDD VDD _00146_ sky130_fd_sc_hd__inv_1
X_06260_ stage3_in_r\[15\] VSS VSS VDD VDD _00143_ sky130_fd_sc_hd__inv_1
X_06261_ _00145_ _00322_ VSS VSS VDD VDD _03044_ sky130_fd_sc_hd__xor2_1
X_06262_ net459 _03044_ VSS VSS VDD VDD _01326_ sky130_fd_sc_hd__xnor2_1
X_06263_ _01309_ net459 _00294_ VSS VSS VDD VDD _00347_ sky130_fd_sc_hd__mux2i_1
X_06264_ _00351_ VSS VSS VDD VDD _00348_ sky130_fd_sc_hd__inv_1
X_06265_ _03026_ _03001_ VSS VSS VDD VDD _03045_ sky130_fd_sc_hd__nor2_1
X_06266_ _01232_ _03045_ VSS VSS VDD VDD _03046_ sky130_fd_sc_hd__nand2_1
X_06267_ _01232_ _01241_ _03045_ VSS VSS VDD VDD _03047_ sky130_fd_sc_hd__nand3_1
X_06268_ _01218_ _02902_ _02995_ _01231_ _01217_ VSS VSS VDD
+ VDD _03048_ sky130_fd_sc_hd__a221oi_2
X_06269_ _02996_ _03048_ _01296_ VSS VSS VDD VDD _03049_ sky130_fd_sc_hd__o21bai_1
X_06270_ _01318_ _03049_ _01317_ VSS VSS VDD VDD _03050_ sky130_fd_sc_hd__a21oi_2
X_06271_ _02924_ _03046_ _03047_ _03050_ VSS VSS VDD VDD _03051_
+ sky130_fd_sc_hd__o211ai_2
X_06272_ _01332_ _03051_ VSS VSS VDD VDD _01682_ sky130_fd_sc_hd__xor2_1
X_06273_ _01682_ VSS VSS VDD VDD _01685_ sky130_fd_sc_hd__inv_1
X_06274_ _01289_ _01307_ _03009_ _03012_ VSS VSS VDD VDD _03052_
+ sky130_fd_sc_hd__or4_1
X_06275_ _01308_ _01307_ _03052_ VSS VSS VDD VDD _03053_ sky130_fd_sc_hd__o21ai_0
X_06276_ _03035_ net425 _03016_ _03053_ VSS VSS VDD VDD _03054_
+ sky130_fd_sc_hd__o31a_1
X_06277_ _01325_ _03054_ VSS VSS VDD VDD _01681_ sky130_fd_sc_hd__xnor2_1
X_06278_ _01682_ _01681_ VSS VSS VDD VDD _03055_ sky130_fd_sc_hd__xor2_1
X_06279_ _01674_ _03018_ VSS VSS VDD VDD _03056_ sky130_fd_sc_hd__nand2b_1
X_06280_ _01599_ _01674_ _03003_ _03037_ _03056_ VSS VSS VDD
+ VDD _03057_ sky130_fd_sc_hd__o311ai_1
X_06281_ _01680_ _03057_ VSS VSS VDD VDD _03058_ sky130_fd_sc_hd__nor2b_1
X_06282_ _03055_ _03058_ VSS VSS VDD VDD _01554_ sky130_fd_sc_hd__xor2_1
X_06283_ _01554_ VSS VSS VDD VDD _01557_ sky130_fd_sc_hd__inv_1
X_06284_ net431 _01334_ VSS VSS VDD VDD _01338_ sky130_fd_sc_hd__xor2_1
X_06285_ net426 _00310_ VSS VSS VDD VDD _03059_ sky130_fd_sc_hd__xnor2_1
X_06286_ net431 _00046_ _03059_ VSS VSS VDD VDD _03060_ sky130_fd_sc_hd__or3_1
X_06287_ net430 _00010_ _03060_ VSS VSS VDD VDD _03061_ sky130_fd_sc_hd__o21ai_0
X_06288_ net431 _03059_ _03061_ _01299_ VSS VSS VDD VDD _00358_
+ sky130_fd_sc_hd__a22oi_1
X_06289_ _01301_ net431 VSS VSS VDD VDD _00359_ sky130_fd_sc_hd__nand2_1
X_06290_ net429 _03044_ _00323_ VSS VSS VDD VDD _00368_ sky130_fd_sc_hd__mux2_2
X_06291_ net459 _01311_ VSS VSS VDD VDD _00369_ sky130_fd_sc_hd__nand2_1
X_06292_ _01218_ _01297_ _02902_ VSS VSS VDD VDD _03062_ sky130_fd_sc_hd__nand3_1
X_06293_ _03025_ _03062_ _03026_ VSS VSS VDD VDD _03063_ sky130_fd_sc_hd__a21oi_1
X_06294_ _01317_ _03063_ _01332_ VSS VSS VDD VDD _03064_ sky130_fd_sc_hd__o21a_1
X_06295_ _01332_ _02901_ _03045_ _03064_ VSS VSS VDD VDD _03065_
+ sky130_fd_sc_hd__a31oi_1
X_06296_ _01331_ _03065_ VSS VSS VDD VDD _03066_ sky130_fd_sc_hd__nor2b_1
X_06297_ _01351_ _03066_ VSS VSS VDD VDD _01688_ sky130_fd_sc_hd__xnor2_1
X_06298_ _01688_ VSS VSS VDD VDD _01691_ sky130_fd_sc_hd__inv_1
X_06299_ _01308_ _01325_ VSS VSS VDD VDD _03067_ sky130_fd_sc_hd__nand2_1
X_06300_ _01308_ _03028_ _01307_ VSS VSS VDD VDD _03068_ sky130_fd_sc_hd__a21o_1
X_06301_ _01325_ _03068_ _01324_ VSS VSS VDD VDD _03069_ sky130_fd_sc_hd__a21oi_1
X_06302_ _03031_ _03034_ _03067_ _03069_ VSS VSS VDD VDD _03070_
+ sky130_fd_sc_hd__o31ai_1
X_06303_ _01344_ _03070_ VSS VSS VDD VDD _01687_ sky130_fd_sc_hd__xor2_1
X_06304_ _01688_ net422 VSS VSS VDD VDD _03071_ sky130_fd_sc_hd__xnor2_1
X_06305_ _03055_ _03058_ _01686_ VSS VSS VDD VDD _03072_ sky130_fd_sc_hd__o21bai_1
X_06306_ _03071_ _03072_ VSS VSS VDD VDD _01352_ sky130_fd_sc_hd__xor2_1
X_06307_ _01352_ VSS VSS VDD VDD _01355_ sky130_fd_sc_hd__inv_1
X_06308_ _01336_ _01333_ VSS VSS VDD VDD _01357_ sky130_fd_sc_hd__or2_2
X_06309_ _01357_ VSS VSS VDD VDD _01359_ sky130_fd_sc_hd__inv_1
X_06310_ _01334_ net431 _00310_ VSS VSS VDD VDD _00379_ sky130_fd_sc_hd__mux2i_1
X_06311_ _01320_ net431 VSS VSS VDD VDD _00380_ sky130_fd_sc_hd__nand2_1
X_06312_ net459 _01366_ VSS VSS VDD VDD _01369_ sky130_fd_sc_hd__xor2_1
X_06313_ _01523_ _00144_ VSS VSS VDD VDD _03073_ sky130_fd_sc_hd__xnor2_1
X_06314_ _01205_ _00322_ VSS VSS VDD VDD _03074_ sky130_fd_sc_hd__nand2_1
X_06315_ _00322_ _01205_ VSS VSS VDD VDD _03075_ sky130_fd_sc_hd__nor2b_1
X_06316_ _03073_ _03075_ net459 VSS VSS VDD VDD _03076_ sky130_fd_sc_hd__o21ai_0
X_06317_ net459 _03073_ _03074_ _03076_ VSS VSS VDD VDD _00389_
+ sky130_fd_sc_hd__o31a_1
X_06318_ net459 _01327_ VSS VSS VDD VDD _00390_ sky130_fd_sc_hd__nand2_1
X_06319_ _01332_ _03051_ _01331_ VSS VSS VDD VDD _03077_ sky130_fd_sc_hd__a21oi_1
X_06320_ _03077_ _01351_ VSS VSS VDD VDD _03078_ sky130_fd_sc_hd__nand2b_1
X_06321_ _01375_ _01350_ VSS VSS VDD VDD _03079_ sky130_fd_sc_hd__nor2_1
X_06322_ _01332_ _03051_ _01350_ _01331_ VSS VSS VDD VDD _03080_
+ sky130_fd_sc_hd__a211oi_2
X_06323_ _01351_ _01350_ _01375_ VSS VSS VDD VDD _03081_ sky130_fd_sc_hd__o21ai_0
X_06324_ _03080_ _03081_ VSS VSS VDD VDD _03082_ sky130_fd_sc_hd__nor2_1
X_06325_ _03078_ _03079_ _03082_ VSS VSS VDD VDD _01699_ sky130_fd_sc_hd__a21oi_1
X_06326_ _01699_ VSS VSS VDD VDD _01702_ sky130_fd_sc_hd__inv_1
X_06327_ _01308_ _01307_ _01325_ VSS VSS VDD VDD _03083_ sky130_fd_sc_hd__o21a_1
X_06328_ _03052_ _03083_ _01324_ VSS VSS VDD VDD _03084_ sky130_fd_sc_hd__a21oi_1
X_06329_ net425 _03016_ _03067_ _03084_ VSS VSS VDD VDD _03085_
+ sky130_fd_sc_hd__o31ai_2
X_06330_ _01344_ _03085_ _01343_ VSS VSS VDD VDD _03086_ sky130_fd_sc_hd__a21oi_1
X_06331_ _01364_ _03086_ VSS VSS VDD VDD _03087_ sky130_fd_sc_hd__xor2_1
X_06332_ _03087_ VSS VSS VDD VDD _01698_ sky130_fd_sc_hd__inv_1
X_06333_ _01699_ _01698_ VSS VSS VDD VDD _03088_ sky130_fd_sc_hd__xnor2_1
X_06334_ _01680_ _01686_ _01692_ VSS VSS VDD VDD _03089_ sky130_fd_sc_hd__nor3_1
X_06335_ _01686_ _03055_ VSS VSS VDD VDD _03090_ sky130_fd_sc_hd__nand2b_1
X_06336_ _03071_ _03090_ _01692_ VSS VSS VDD VDD _03091_ sky130_fd_sc_hd__a21oi_1
X_06337_ _03057_ _03089_ _03091_ VSS VSS VDD VDD _03092_ sky130_fd_sc_hd__a21oi_1
X_06338_ _03088_ _03092_ VSS VSS VDD VDD _01376_ sky130_fd_sc_hd__xor2_1
X_06339_ _01376_ VSS VSS VDD VDD _01379_ sky130_fd_sc_hd__inv_1
X_06340_ net431 _01339_ VSS VSS VDD VDD _00401_ sky130_fd_sc_hd__nand2_1
X_06341_ _01368_ _01365_ VSS VSS VDD VDD _01391_ sky130_fd_sc_hd__or2_2
X_06342_ _01391_ VSS VSS VDD VDD _01393_ sky130_fd_sc_hd__inv_1
X_06343_ _01366_ net459 _00144_ VSS VSS VDD VDD _00410_ sky130_fd_sc_hd__mux2i_1
X_06344_ net459 _01346_ VSS VSS VDD VDD _00411_ sky130_fd_sc_hd__nand2_1
X_06345_ _01374_ VSS VSS VDD VDD _03093_ sky130_fd_sc_hd__inv_1
X_06346_ _01331_ _01350_ _01374_ VSS VSS VDD VDD _03094_ sky130_fd_sc_hd__nor3_1
X_06347_ _03093_ _03081_ _03094_ _03065_ VSS VSS VDD VDD _03095_
+ sky130_fd_sc_hd__a22o_1
X_06348_ _01398_ _03095_ VSS VSS VDD VDD _01710_ sky130_fd_sc_hd__xnor2_1
X_06349_ _01710_ VSS VSS VDD VDD _01713_ sky130_fd_sc_hd__inv_1
X_06350_ _03088_ _03092_ _01703_ VSS VSS VDD VDD _03096_ sky130_fd_sc_hd__a21oi_1
X_06351_ _01344_ _03070_ _01343_ VSS VSS VDD VDD _03097_ sky130_fd_sc_hd__a21o_1
X_06352_ _01364_ _03097_ _01363_ VSS VSS VDD VDD _03098_ sky130_fd_sc_hd__a21oi_2
X_06353_ _01389_ _03098_ VSS VSS VDD VDD _01709_ sky130_fd_sc_hd__xnor2_2
X_06354_ _01710_ _01709_ VSS VSS VDD VDD _03099_ sky130_fd_sc_hd__xnor2_1
X_06355_ _03096_ _03099_ VSS VSS VDD VDD _01399_ sky130_fd_sc_hd__xnor2_1
X_06356_ _01399_ VSS VSS VDD VDD _01402_ sky130_fd_sc_hd__inv_1
X_06357_ _00424_ VSS VSS VDD VDD _00420_ sky130_fd_sc_hd__inv_1
X_06358_ net459 _01370_ VSS VSS VDD VDD _00433_ sky130_fd_sc_hd__nand2_1
Xinput134 in_flat[76] VSS VSS VDD VDD net133 sky130_fd_sc_hd__clkdlybuf4s50_1
X_06360_ _01397_ VSS VSS VDD VDD _03101_ sky130_fd_sc_hd__inv_1
X_06361_ _01398_ VSS VSS VDD VDD _03102_ sky130_fd_sc_hd__inv_1
X_06362_ _03102_ _01419_ _03093_ VSS VSS VDD VDD _03103_ sky130_fd_sc_hd__nor3_1
X_06363_ _03102_ _01419_ _03101_ _03103_ VSS VSS VDD VDD _03104_
+ sky130_fd_sc_hd__a31oi_1
X_06364_ _01419_ _03101_ _03104_ VSS VSS VDD VDD _03105_ sky130_fd_sc_hd__o21ai_0
X_06365_ _03102_ _01419_ _03080_ _03081_ VSS VSS VDD VDD _03106_
+ sky130_fd_sc_hd__nor4_1
X_06366_ _03080_ _03081_ _01419_ _03093_ _03101_ VSS VSS VDD
+ VDD _03107_ sky130_fd_sc_hd__o2111ai_1
X_06367_ _03105_ _03106_ _03107_ VSS VSS VDD VDD _01724_ sky130_fd_sc_hd__nor3b_1
X_06368_ _01411_ VSS VSS VDD VDD _03108_ sky130_fd_sc_hd__inv_1
X_06369_ _01364_ _01363_ _01389_ VSS VSS VDD VDD _03109_ sky130_fd_sc_hd__o21a_1
X_06370_ _01388_ _03109_ VSS VSS VDD VDD _03110_ sky130_fd_sc_hd__nor2_1
X_06371_ _01344_ _03085_ _01388_ _01363_ _01343_ VSS VSS VDD
+ VDD _03111_ sky130_fd_sc_hd__a2111oi_4
X_06372_ _03110_ _03111_ VSS VSS VDD VDD _03112_ sky130_fd_sc_hd__nor2_2
X_06373_ _03108_ _03112_ VSS VSS VDD VDD _01720_ sky130_fd_sc_hd__xnor2_4
X_06374_ net421 _01720_ VSS VSS VDD VDD _03113_ sky130_fd_sc_hd__xor2_1
X_06375_ _03096_ _03099_ VSS VSS VDD VDD _03114_ sky130_fd_sc_hd__nor2b_1
X_06376_ _01714_ _03114_ VSS VSS VDD VDD _03115_ sky130_fd_sc_hd__nor2_1
X_06377_ _03113_ _03115_ VSS VSS VDD VDD _01420_ sky130_fd_sc_hd__xnor2_1
X_06378_ _01420_ VSS VSS VDD VDD _01423_ sky130_fd_sc_hd__inv_1
X_06379_ _00453_ VSS VSS VDD VDD _00449_ sky130_fd_sc_hd__inv_1
X_06380_ _03102_ _03095_ _03101_ VSS VSS VDD VDD _03116_ sky130_fd_sc_hd__o21ai_0
X_06381_ _01419_ _03116_ _01418_ VSS VSS VDD VDD _03117_ sky130_fd_sc_hd__a21oi_1
X_06382_ _01438_ _03117_ VSS VSS VDD VDD _01732_ sky130_fd_sc_hd__xnor2_1
X_06383_ _01732_ VSS VSS VDD VDD _01735_ sky130_fd_sc_hd__inv_1
X_06384_ _01714_ _03113_ _01725_ VSS VSS VDD VDD _03118_ sky130_fd_sc_hd__a21oi_1
X_06385_ _03099_ _03113_ VSS VSS VDD VDD _03119_ sky130_fd_sc_hd__and2_1
X_06386_ _03088_ _03092_ _03119_ VSS VSS VDD VDD _03120_ sky130_fd_sc_hd__nand3_2
X_06387_ _01703_ _03119_ VSS VSS VDD VDD _03121_ sky130_fd_sc_hd__nand2_1
X_06388_ _03118_ _03120_ _03121_ VSS VSS VDD VDD _03122_ sky130_fd_sc_hd__nand3_1
X_06389_ _01389_ _01411_ VSS VSS VDD VDD _03123_ sky130_fd_sc_hd__nand2_1
X_06390_ _01411_ _01388_ _01410_ VSS VSS VDD VDD _03124_ sky130_fd_sc_hd__a21oi_1
X_06391_ _03098_ _03123_ _03124_ VSS VSS VDD VDD _03125_ sky130_fd_sc_hd__o21ai_1
X_06392_ _01432_ _03125_ VSS VSS VDD VDD _03126_ sky130_fd_sc_hd__xnor2_1
X_06393_ _01732_ net419 VSS VSS VDD VDD _03127_ sky130_fd_sc_hd__xnor2_1
X_06394_ _03122_ _03127_ VSS VSS VDD VDD _01559_ sky130_fd_sc_hd__xnor2_1
X_06395_ _01559_ VSS VSS VDD VDD _01562_ sky130_fd_sc_hd__inv_1
X_06396_ _01398_ _01397_ _01419_ VSS VSS VDD VDD _03128_ sky130_fd_sc_hd__o21a_1
X_06397_ _01374_ _01397_ _03082_ _03128_ VSS VSS VDD VDD _03129_
+ sky130_fd_sc_hd__o31a_1
X_06398_ _01418_ _03129_ _01438_ VSS VSS VDD VDD _03130_ sky130_fd_sc_hd__o21ai_0
X_06399_ _01455_ _01437_ VSS VSS VDD VDD _03131_ sky130_fd_sc_hd__nor2_1
X_06400_ _01438_ _01437_ _01455_ VSS VSS VDD VDD _03132_ sky130_fd_sc_hd__o21ai_0
X_06401_ _03132_ VSS VSS VDD VDD _03133_ sky130_fd_sc_hd__inv_1
X_06402_ _01418_ _01437_ _03129_ _03133_ VSS VSS VDD VDD _03134_
+ sky130_fd_sc_hd__o31a_1
X_06403_ _03130_ _03131_ _03134_ VSS VSS VDD VDD _01738_ sky130_fd_sc_hd__a21oi_2
X_06404_ _01738_ VSS VSS VDD VDD _01741_ sky130_fd_sc_hd__inv_1
X_06405_ net419 VSS VSS VDD VDD _01731_ sky130_fd_sc_hd__inv_1
X_06406_ _03118_ _03120_ _03121_ _03127_ VSS VSS VDD VDD _03135_
+ sky130_fd_sc_hd__a31oi_1
X_06407_ _01736_ _03135_ VSS VSS VDD VDD _03136_ sky130_fd_sc_hd__nor2_1
X_06408_ _01411_ _01432_ _01447_ VSS VSS VDD VDD _03137_ sky130_fd_sc_hd__nand3_1
X_06409_ _03110_ _03111_ _03137_ VSS VSS VDD VDD _03138_ sky130_fd_sc_hd__nor3_1
X_06410_ _01447_ _01431_ VSS VSS VDD VDD _03139_ sky130_fd_sc_hd__nand2_1
X_06411_ _01432_ _01447_ _01410_ VSS VSS VDD VDD _03140_ sky130_fd_sc_hd__nand3_1
X_06412_ _03139_ _03140_ VSS VSS VDD VDD _03141_ sky130_fd_sc_hd__nand2_1
X_06413_ _01410_ VSS VSS VDD VDD _03142_ sky130_fd_sc_hd__inv_1
X_06414_ _03108_ _03110_ _03111_ _03142_ VSS VSS VDD VDD _03143_
+ sky130_fd_sc_hd__o31ai_1
X_06415_ _01432_ _03143_ _01431_ _01447_ VSS VSS VDD VDD _03144_
+ sky130_fd_sc_hd__a211oi_2
X_06416_ _03138_ _03141_ _03144_ VSS VSS VDD VDD _01737_ sky130_fd_sc_hd__nor3_4
X_06417_ _01738_ _01737_ VSS VSS VDD VDD _03145_ sky130_fd_sc_hd__xnor2_1
X_06418_ _03136_ _03145_ VSS VSS VDD VDD _01564_ sky130_fd_sc_hd__xnor2_1
X_06419_ _01564_ VSS VSS VDD VDD _01567_ sky130_fd_sc_hd__inv_1
X_06420_ _03093_ _03081_ _03094_ _03065_ _03102_ VSS VSS VDD
+ VDD _03146_ sky130_fd_sc_hd__a221oi_1
X_06421_ _01397_ _03146_ _01419_ _01438_ _01455_ VSS VSS VDD
+ VDD _03147_ sky130_fd_sc_hd__o2111ai_1
X_06422_ _01438_ _01455_ _01418_ VSS VSS VDD VDD _03148_ sky130_fd_sc_hd__and3_1
X_06423_ _01455_ _01437_ _03148_ VSS VSS VDD VDD _03149_ sky130_fd_sc_hd__a21oi_1
X_06424_ _01454_ _03147_ _03149_ VSS VSS VDD VDD _03150_ sky130_fd_sc_hd__and3b_1
X_06425_ _01473_ _03150_ VSS VSS VDD VDD _01744_ sky130_fd_sc_hd__xnor2_1
X_06426_ _01744_ VSS VSS VDD VDD _01747_ sky130_fd_sc_hd__inv_1
X_06427_ _01738_ _01737_ VSS VSS VDD VDD _03151_ sky130_fd_sc_hd__xor2_1
X_06428_ _03118_ _03120_ _03121_ _03127_ _03151_ VSS VSS VDD
+ VDD _03152_ sky130_fd_sc_hd__a311oi_2
X_06429_ _01736_ _03145_ _01742_ VSS VSS VDD VDD _03153_ sky130_fd_sc_hd__a21o_1
X_06430_ _03152_ _03153_ VSS VSS VDD VDD _03154_ sky130_fd_sc_hd__or2_1
X_06431_ _03098_ _03123_ _01411_ _01388_ VSS VSS VDD VDD _03155_
+ sky130_fd_sc_hd__a2bb2oi_1
X_06432_ _01410_ _01431_ _01446_ VSS VSS VDD VDD _03156_ sky130_fd_sc_hd__nor3_1
X_06433_ _01432_ _01431_ _01446_ VSS VSS VDD VDD _03157_ sky130_fd_sc_hd__nor3_1
X_06434_ _01447_ _01446_ VSS VSS VDD VDD _03158_ sky130_fd_sc_hd__nor2_1
X_06435_ _03155_ _03156_ _03157_ _03158_ VSS VSS VDD VDD _03159_
+ sky130_fd_sc_hd__a211oi_1
X_06436_ _01464_ _03159_ VSS VSS VDD VDD _01743_ sky130_fd_sc_hd__xor2_1
X_06437_ _01747_ net417 VSS VSS VDD VDD _03160_ sky130_fd_sc_hd__xnor2_1
X_06438_ _03154_ _03160_ VSS VSS VDD VDD _01569_ sky130_fd_sc_hd__xnor2_1
X_06439_ _01569_ VSS VSS VDD VDD _01572_ sky130_fd_sc_hd__inv_1
X_06440_ _02249_ VSS VSS VDD VDD _00912_ sky130_fd_sc_hd__inv_1
X_06441_ _01454_ _01491_ VSS VSS VDD VDD _03161_ sky130_fd_sc_hd__nand2b_1
X_06442_ _01491_ _01473_ VSS VSS VDD VDD _03162_ sky130_fd_sc_hd__nor2b_1
X_06443_ _01418_ _01437_ _03129_ _03133_ _03162_ VSS VSS VDD
+ VDD _03163_ sky130_fd_sc_hd__o311ai_0
X_06444_ _01491_ VSS VSS VDD VDD _03164_ sky130_fd_sc_hd__inv_1
X_06445_ _01473_ _03164_ _01472_ VSS VSS VDD VDD _03165_ sky130_fd_sc_hd__nor3_1
X_06446_ _03164_ _01472_ _03162_ _01454_ _03165_ VSS VSS VDD
+ VDD _03166_ sky130_fd_sc_hd__a221oi_1
X_06447_ _01472_ _03134_ _03161_ _03163_ _03166_ VSS VSS VDD
+ VDD _01750_ sky130_fd_sc_hd__o311ai_4
X_06448_ _01750_ VSS VSS VDD VDD _01753_ sky130_fd_sc_hd__inv_1
X_06449_ _03160_ VSS VSS VDD VDD _03167_ sky130_fd_sc_hd__inv_1
X_06450_ _03154_ _03167_ _01748_ VSS VSS VDD VDD _03168_ sky130_fd_sc_hd__a21oi_1
X_06451_ _01446_ _03138_ _03141_ _01464_ VSS VSS VDD VDD _03169_
+ sky130_fd_sc_hd__o31ai_1
X_06452_ _01463_ _03169_ VSS VSS VDD VDD _03170_ sky130_fd_sc_hd__nand2b_1
X_06453_ _01481_ _03170_ VSS VSS VDD VDD _01749_ sky130_fd_sc_hd__xor2_2
X_06454_ _01750_ net416 VSS VSS VDD VDD _03171_ sky130_fd_sc_hd__xnor2_2
X_06455_ _03168_ _03171_ VSS VSS VDD VDD _01577_ sky130_fd_sc_hd__xor2_1
X_06456_ net426 VSS VSS VDD VDD _02272_ sky130_fd_sc_hd__inv_1
X_06457_ _01454_ _01472_ _01490_ VSS VSS VDD VDD _03172_ sky130_fd_sc_hd__nor3_1
X_06458_ _01473_ _01472_ VSS VSS VDD VDD _03173_ sky130_fd_sc_hd__or2_2
X_06459_ _01491_ _03173_ _01490_ VSS VSS VDD VDD _03174_ sky130_fd_sc_hd__a21oi_1
X_06460_ _03147_ _03149_ _03172_ _03174_ VSS VSS VDD VDD _03175_
+ sky130_fd_sc_hd__a31oi_1
X_06461_ _01512_ _03175_ VSS VSS VDD VDD _01755_ sky130_fd_sc_hd__xor2_1
X_06462_ _01755_ VSS VSS VDD VDD _01759_ sky130_fd_sc_hd__inv_1
X_06463_ _03160_ _03171_ VSS VSS VDD VDD _03176_ sky130_fd_sc_hd__nor2b_4
X_06464_ _01748_ _03171_ _03176_ _03154_ _01754_ VSS VSS VDD
+ VDD _03177_ sky130_fd_sc_hd__a221oi_2
X_06465_ _01758_ _03177_ VSS VSS VDD VDD _01582_ sky130_fd_sc_hd__xnor2_1
X_06466_ _01454_ _03134_ _01473_ VSS VSS VDD VDD _03178_ sky130_fd_sc_hd__o21a_1
X_06467_ _01472_ _03178_ _01491_ VSS VSS VDD VDD _03179_ sky130_fd_sc_hd__o21ai_0
X_06468_ _01490_ _03179_ VSS VSS VDD VDD _03180_ sky130_fd_sc_hd__nand2b_1
X_06469_ _01512_ _03180_ _01511_ VSS VSS VDD VDD _03181_ sky130_fd_sc_hd__a21oi_1
X_06470_ _01534_ _03181_ VSS VSS VDD VDD _01535_ sky130_fd_sc_hd__xnor2_1
X_06471_ _01535_ VSS VSS VDD VDD _01539_ sky130_fd_sc_hd__inv_1
X_06472_ _01758_ VSS VSS VDD VDD _03182_ sky130_fd_sc_hd__inv_1
X_06473_ _03152_ _03153_ _03176_ _03182_ VSS VSS VDD VDD _03183_
+ sky130_fd_sc_hd__o211a_4
X_06474_ _01758_ _01754_ VSS VSS VDD VDD _03184_ sky130_fd_sc_hd__nor2b_1
X_06475_ _03182_ _01748_ _03171_ _03184_ VSS VSS VDD VDD _03185_
+ sky130_fd_sc_hd__a31o_2
X_06476_ _01760_ _03183_ _03185_ VSS VSS VDD VDD _03186_ sky130_fd_sc_hd__nor3_2
X_06477_ _01538_ _03186_ VSS VSS VDD VDD _01587_ sky130_fd_sc_hd__xnor2_1
X_06478_ _01464_ _01481_ _01502_ VSS VSS VDD VDD _03187_ sky130_fd_sc_hd__nand3_1
X_06479_ _03155_ _03156_ _03157_ _03158_ _03187_ VSS VSS VDD
+ VDD _03188_ sky130_fd_sc_hd__a2111o_1
X_06480_ _01502_ _01480_ VSS VSS VDD VDD _03189_ sky130_fd_sc_hd__nand2_1
X_06481_ _01481_ _01502_ _01463_ VSS VSS VDD VDD _03190_ sky130_fd_sc_hd__nand3_1
X_06482_ stage3_in_r\[29\] VSS VSS VDD VDD _00309_ sky130_fd_sc_hd__inv_1
X_06483_ net430 net428 VSS VSS VDD VDD _03191_ sky130_fd_sc_hd__nor2_1
X_06484_ _02248_ net428 _03191_ _01492_ VSS VSS VDD VDD _03192_
+ sky130_fd_sc_hd__a211oi_1
X_06485_ _01516_ _00501_ VSS VSS VDD VDD _03193_ sky130_fd_sc_hd__xor2_1
X_06486_ _01515_ _03193_ VSS VSS VDD VDD _03194_ sky130_fd_sc_hd__xnor2_1
X_06487_ _03192_ _03194_ VSS VSS VDD VDD _03195_ sky130_fd_sc_hd__xnor2_1
X_06488_ _01521_ _03195_ VSS VSS VDD VDD _03196_ sky130_fd_sc_hd__nand2_1
X_06489_ _03188_ _03189_ _03190_ _03196_ VSS VSS VDD VDD _03197_
+ sky130_fd_sc_hd__a31oi_1
X_06490_ _01501_ _01520_ _03195_ VSS VSS VDD VDD _03198_ sky130_fd_sc_hd__nor3_1
X_06491_ _03188_ _03189_ _03190_ _03198_ VSS VSS VDD VDD _03199_
+ sky130_fd_sc_hd__and4_1
X_06492_ _01521_ _01501_ VSS VSS VDD VDD _03200_ sky130_fd_sc_hd__and2_1
X_06493_ _01520_ _03200_ _03195_ VSS VSS VDD VDD _03201_ sky130_fd_sc_hd__o21ai_0
X_06494_ _01521_ _01520_ _03195_ _03201_ VSS VSS VDD VDD _03202_
+ sky130_fd_sc_hd__o31ai_1
X_06495_ _03197_ _03199_ _03202_ VSS VSS VDD VDD _03203_ sky130_fd_sc_hd__nor3_1
X_06496_ stage3_in_r\[14\] _01525_ VSS VSS VDD VDD _03204_
+ sky130_fd_sc_hd__nor2_1
X_06497_ _01503_ _03204_ VSS VSS VDD VDD _03205_ sky130_fd_sc_hd__nand2_1
X_06498_ _01503_ stage3_in_r\[14\] VSS VSS VDD VDD _03206_
+ sky130_fd_sc_hd__nor2_1
X_06499_ _01525_ _03206_ net459 VSS VSS VDD VDD _03207_ sky130_fd_sc_hd__o21ai_0
X_06500_ net459 _03205_ _03207_ VSS VSS VDD VDD _03208_ sky130_fd_sc_hd__o21ai_0
X_06501_ _01523_ _01503_ VSS VSS VDD VDD _03209_ sky130_fd_sc_hd__xnor2_1
X_06502_ net459 _01482_ VSS VSS VDD VDD _03210_ sky130_fd_sc_hd__xnor2_1
X_06503_ stage3_in_r\[13\] _03209_ _03210_ VSS VSS VDD VDD
+ _03211_ sky130_fd_sc_hd__nor3_1
X_06504_ _01529_ _00505_ VSS VSS VDD VDD _03212_ sky130_fd_sc_hd__xor2_1
X_06505_ _01528_ _03212_ VSS VSS VDD VDD _03213_ sky130_fd_sc_hd__xnor2_1
X_06506_ _03211_ _03213_ VSS VSS VDD VDD _03214_ sky130_fd_sc_hd__xnor2_1
X_06507_ _03208_ _03214_ VSS VSS VDD VDD _03215_ sky130_fd_sc_hd__xnor2_1
X_06508_ _01512_ _03175_ _01511_ VSS VSS VDD VDD _03216_ sky130_fd_sc_hd__a21o_1
X_06509_ _01534_ _03216_ _01533_ VSS VSS VDD VDD _03217_ sky130_fd_sc_hd__a21oi_1
X_06510_ _03215_ _03217_ VSS VSS VDD VDD _03218_ sky130_fd_sc_hd__xnor2_1
X_06511_ net414 _03218_ VSS VSS VDD VDD _03219_ sky130_fd_sc_hd__xnor2_1
X_06512_ _01538_ VSS VSS VDD VDD _03220_ sky130_fd_sc_hd__inv_1
X_06513_ _03183_ _03185_ net413 _03220_ VSS VSS VDD VDD _03221_
+ sky130_fd_sc_hd__o211a_1
X_06514_ _01538_ _01760_ VSS VSS VDD VDD _03222_ sky130_fd_sc_hd__nor2b_1
X_06515_ _01540_ _03222_ net413 VSS VSS VDD VDD _03223_ sky130_fd_sc_hd__o21a_1
X_06516_ _01540_ _01760_ _03219_ VSS VSS VDD VDD _03224_ sky130_fd_sc_hd__or3_1
X_06517_ _01540_ _01538_ VSS VSS VDD VDD _03225_ sky130_fd_sc_hd__nand2b_1
X_06518_ _03183_ _03185_ _03224_ _03225_ net413 VSS VSS VDD
+ VDD _03226_ sky130_fd_sc_hd__o32ai_1
X_06519_ _03221_ _03223_ _03226_ VSS VSS VDD VDD _01592_ sky130_fd_sc_hd__or3_1
X_06520_ net458 _03043_ VSS VSS VDD VDD _01117_ sky130_fd_sc_hd__nor2_1
X_06521_ _01666_ stage3_in_r\[0\] net445 _01665_ VSS VSS VDD
+ VDD _03227_ sky130_fd_sc_hd__a31o_2
X_06522_ _01662_ _03227_ _01661_ VSS VSS VDD VDD _03228_ sky130_fd_sc_hd__a21oi_1
X_06523_ _01651_ _01654_ _01658_ VSS VSS VDD VDD _03229_ sky130_fd_sc_hd__nand3_1
X_06524_ _01654_ _01657_ _01653_ VSS VSS VDD VDD _03230_ sky130_fd_sc_hd__a21o_1
X_06525_ _01651_ _03230_ _01650_ VSS VSS VDD VDD _03231_ sky130_fd_sc_hd__a21oi_1
X_06526_ _03228_ _03229_ _03231_ VSS VSS VDD VDD _03232_ sky130_fd_sc_hd__o21ai_0
X_06527_ _01645_ _03232_ _01644_ VSS VSS VDD VDD _03233_ sky130_fd_sc_hd__a21oi_1
X_06528_ _01627_ _01633_ _01639_ VSS VSS VDD VDD _03234_ sky130_fd_sc_hd__nand3_1
X_06529_ _01633_ _01638_ _01632_ VSS VSS VDD VDD _03235_ sky130_fd_sc_hd__a21o_1
X_06530_ _01627_ _03235_ _01626_ VSS VSS VDD VDD _03236_ sky130_fd_sc_hd__a21oi_1
X_06531_ _03233_ _03234_ _03236_ VSS VSS VDD VDD _03237_ sky130_fd_sc_hd__o21ai_0
X_06532_ _01615_ _01620_ _01614_ _01602_ _01608_ VSS VSS VDD
+ VDD _03238_ sky130_fd_sc_hd__a2111o_1
X_06533_ _01615_ _01621_ _03237_ _03238_ VSS VSS VDD VDD _03239_
+ sky130_fd_sc_hd__a31oi_1
X_06534_ _01609_ _01608_ _01603_ VSS VSS VDD VDD _03240_ sky130_fd_sc_hd__o21a_1
X_06535_ _01602_ _03240_ VSS VSS VDD VDD _03241_ sky130_fd_sc_hd__nor2_1
X_06536_ _01276_ VSS VSS VDD VDD _03242_ sky130_fd_sc_hd__inv_1
X_06537_ _03041_ _03239_ _03241_ _03242_ VSS VSS VDD VDD _03243_
+ sky130_fd_sc_hd__o31ai_1
X_06538_ _01597_ net418 VSS VSS VDD VDD _01113_ sky130_fd_sc_hd__xor2_1
X_06539_ _01113_ VSS VSS VDD VDD _01116_ sky130_fd_sc_hd__inv_1
X_06540_ _01597_ net418 _01596_ VSS VSS VDD VDD _03244_ sky130_fd_sc_hd__a21oi_1
X_06541_ _01672_ _03244_ VSS VSS VDD VDD _01764_ sky130_fd_sc_hd__xnor2_1
X_06542_ _01764_ VSS VSS VDD VDD _01767_ sky130_fd_sc_hd__inv_1
X_06543_ _01596_ _01597_ _01672_ VSS VSS VDD VDD _03245_ sky130_fd_sc_hd__o21ai_0
X_06544_ _01671_ _03245_ VSS VSS VDD VDD _03246_ sky130_fd_sc_hd__nand2b_1
X_06545_ _01596_ _01671_ net418 _03246_ VSS VSS VDD VDD _03247_
+ sky130_fd_sc_hd__o31ai_1
X_06546_ _01678_ _03247_ VSS VSS VDD VDD _01769_ sky130_fd_sc_hd__xnor2_1
X_06547_ _01769_ VSS VSS VDD VDD _01772_ sky130_fd_sc_hd__inv_1
X_06548_ _03239_ _03241_ VSS VSS VDD VDD _03248_ sky130_fd_sc_hd__nor2_1
X_06549_ _01277_ _03248_ VSS VSS VDD VDD _03249_ sky130_fd_sc_hd__xnor2_1
X_06550_ net415 stage3_in_r\[128\] VSS VSS VDD VDD _01122_
+ sky130_fd_sc_hd__nor2b_1
X_06551_ _01596_ _01671_ net418 _03246_ _01678_ VSS VSS VDD
+ VDD _03250_ sky130_fd_sc_hd__o311ai_2
X_06552_ _01677_ _03250_ VSS VSS VDD VDD _03251_ sky130_fd_sc_hd__nor2b_1
X_06553_ _01684_ _03251_ VSS VSS VDD VDD _01774_ sky130_fd_sc_hd__xnor2_1
X_06554_ _01774_ VSS VSS VDD VDD _01777_ sky130_fd_sc_hd__inv_1
X_06555_ _01684_ VSS VSS VDD VDD _03252_ sky130_fd_sc_hd__inv_1
X_06556_ _03252_ _03251_ _01683_ VSS VSS VDD VDD _03253_ sky130_fd_sc_hd__o21bai_1
X_06557_ _01690_ _03253_ VSS VSS VDD VDD _01693_ sky130_fd_sc_hd__xor2_1
X_06558_ _01693_ VSS VSS VDD VDD _01696_ sky130_fd_sc_hd__inv_1
X_06559_ _01690_ _03253_ _01689_ VSS VSS VDD VDD _03254_ sky130_fd_sc_hd__a21o_1
X_06560_ _01701_ _03254_ VSS VSS VDD VDD _01704_ sky130_fd_sc_hd__xor2_1
X_06561_ _01704_ VSS VSS VDD VDD _01707_ sky130_fd_sc_hd__inv_1
X_06562_ _01701_ _03254_ _01700_ VSS VSS VDD VDD _03255_ sky130_fd_sc_hd__a21oi_1
X_06563_ _01712_ _03255_ VSS VSS VDD VDD _01715_ sky130_fd_sc_hd__xnor2_1
X_06564_ _01715_ VSS VSS VDD VDD _01718_ sky130_fd_sc_hd__inv_1
X_06565_ _01684_ _01690_ VSS VSS VDD VDD _03256_ sky130_fd_sc_hd__nand2_1
X_06566_ _01677_ _01684_ _01683_ VSS VSS VDD VDD _03257_ sky130_fd_sc_hd__a21o_1
X_06567_ _01690_ _03257_ VSS VSS VDD VDD _03258_ sky130_fd_sc_hd__nand2_1
X_06568_ _01689_ _01700_ _01711_ VSS VSS VDD VDD _03259_ sky130_fd_sc_hd__nor3_1
X_06569_ _03250_ _03256_ _03258_ _03259_ VSS VSS VDD VDD _03260_
+ sky130_fd_sc_hd__o211ai_1
X_06570_ _01711_ _01712_ VSS VSS VDD VDD _03261_ sky130_fd_sc_hd__nor2_1
X_06571_ _01700_ _01711_ _01701_ VSS VSS VDD VDD _03262_ sky130_fd_sc_hd__nor3_1
X_06572_ _03261_ _03262_ VSS VSS VDD VDD _03263_ sky130_fd_sc_hd__nor2_1
X_06573_ _03260_ _03263_ VSS VSS VDD VDD _03264_ sky130_fd_sc_hd__nand2_1
X_06574_ _01723_ _03264_ VSS VSS VDD VDD _01726_ sky130_fd_sc_hd__xnor2_1
X_06575_ _01726_ VSS VSS VDD VDD _01729_ sky130_fd_sc_hd__inv_1
X_06576_ _01723_ _03260_ _03263_ _01722_ VSS VSS VDD VDD _03265_
+ sky130_fd_sc_hd__a31oi_1
X_06577_ _01734_ _03265_ VSS VSS VDD VDD _01779_ sky130_fd_sc_hd__xnor2_1
X_06578_ _01779_ VSS VSS VDD VDD _01782_ sky130_fd_sc_hd__inv_1
X_06579_ _01723_ _01734_ _01740_ VSS VSS VDD VDD _03266_ sky130_fd_sc_hd__nand3_1
X_06580_ _01722_ _01734_ _01733_ VSS VSS VDD VDD _03267_ sky130_fd_sc_hd__a21o_1
X_06581_ _01740_ _03267_ VSS VSS VDD VDD _03268_ sky130_fd_sc_hd__nand2_1
X_06582_ _03264_ _03266_ _03268_ VSS VSS VDD VDD _03269_ sky130_fd_sc_hd__o21ai_0
X_06583_ _01734_ VSS VSS VDD VDD _03270_ sky130_fd_sc_hd__inv_1
X_06584_ _03270_ _03265_ _01733_ VSS VSS VDD VDD _03271_ sky130_fd_sc_hd__o21bai_1
X_06585_ _01740_ _03271_ VSS VSS VDD VDD _03272_ sky130_fd_sc_hd__nor2_1
X_06586_ _03269_ _03272_ VSS VSS VDD VDD _01784_ sky130_fd_sc_hd__nor2_1
X_06587_ _01784_ VSS VSS VDD VDD _01787_ sky130_fd_sc_hd__inv_1
X_06588_ _01739_ _03269_ VSS VSS VDD VDD _03273_ sky130_fd_sc_hd__or2_2
X_06589_ _01746_ _03273_ VSS VSS VDD VDD _01789_ sky130_fd_sc_hd__xor2_1
X_06590_ _01789_ VSS VSS VDD VDD _01792_ sky130_fd_sc_hd__inv_1
X_06591_ _01746_ _03273_ _01745_ VSS VSS VDD VDD _03274_ sky130_fd_sc_hd__a21oi_1
X_06592_ _01752_ _03274_ VSS VSS VDD VDD _01794_ sky130_fd_sc_hd__xnor2_1
X_06593_ _01794_ VSS VSS VDD VDD _01797_ sky130_fd_sc_hd__inv_1
X_06594_ _01751_ _01752_ VSS VSS VDD VDD _03275_ sky130_fd_sc_hd__nor2_1
X_06595_ _01745_ _01751_ _01746_ VSS VSS VDD VDD _03276_ sky130_fd_sc_hd__nor3_1
X_06596_ _03275_ _03276_ VSS VSS VDD VDD _03277_ sky130_fd_sc_hd__nor2_1
X_06597_ _01739_ _01745_ _01751_ _03269_ _03277_ VSS VSS VDD
+ VDD _03278_ sky130_fd_sc_hd__o41ai_1
X_06598_ _01758_ _03278_ VSS VSS VDD VDD _01799_ sky130_fd_sc_hd__xnor2_1
X_06599_ _01799_ VSS VSS VDD VDD _01802_ sky130_fd_sc_hd__inv_1
X_06600_ _03182_ _03278_ _01757_ VSS VSS VDD VDD _03279_ sky130_fd_sc_hd__o21ba_2
X_06601_ _01538_ _03279_ VSS VSS VDD VDD _01804_ sky130_fd_sc_hd__xnor2_1
X_06602_ _01804_ VSS VSS VDD VDD _01807_ sky130_fd_sc_hd__inv_1
X_06603_ _03220_ _03279_ _01537_ VSS VSS VDD VDD _03280_ sky130_fd_sc_hd__o21ba_2
X_06604_ net413 _03280_ VSS VSS VDD VDD _01812_ sky130_fd_sc_hd__xnor2_1
X_06605_ stage3_in_r\[128\] net415 VSS VSS VDD VDD _01112_
+ sky130_fd_sc_hd__nor2_1
X_06606_ _01876_ _01877_ _01875_ VSS VSS VDD VDD _03281_ sky130_fd_sc_hd__a21oi_1
X_06607_ _03281_ _01874_ VSS VSS VDD VDD _03282_ sky130_fd_sc_hd__nor2b_1
X_06608_ _01873_ _03282_ _01872_ VSS VSS VDD VDD _03283_ sky130_fd_sc_hd__o21ai_0
X_06609_ _01864_ _01866_ VSS VSS VDD VDD _03284_ sky130_fd_sc_hd__nand2_1
X_06610_ _01868_ _01869_ _01867_ VSS VSS VDD VDD _03285_ sky130_fd_sc_hd__a21oi_1
X_06611_ _01864_ _01865_ _01863_ _01856_ VSS VSS VDD VDD _03286_
+ sky130_fd_sc_hd__a211oi_1
X_06612_ _03284_ _03285_ _03286_ VSS VSS VDD VDD _03287_ sky130_fd_sc_hd__o21ai_1
X_06613_ net445 net457 _01880_ _01882_ VSS VSS VDD VDD _03288_
+ sky130_fd_sc_hd__nand4_1
X_06614_ _01880_ _01881_ _01879_ VSS VSS VDD VDD _03289_ sky130_fd_sc_hd__a21oi_1
X_06615_ _01874_ _01876_ _01878_ _01872_ VSS VSS VDD VDD _03290_
+ sky130_fd_sc_hd__nand4_1
X_06616_ _03288_ _03289_ _03290_ VSS VSS VDD VDD _03291_ sky130_fd_sc_hd__a21oi_1
X_06617_ _01857_ _01859_ _03287_ _01871_ _03291_ VSS VSS VDD
+ VDD _03292_ sky130_fd_sc_hd__a2111oi_2
X_06618_ _01864_ _01866_ _01868_ _01870_ _01859_ VSS VSS VDD
+ VDD _03293_ sky130_fd_sc_hd__a41o_1
X_06619_ _01860_ _01859_ _01857_ VSS VSS VDD VDD _03294_ sky130_fd_sc_hd__o21a_1
X_06620_ _03287_ _03293_ _03294_ _01856_ VSS VSS VDD VDD _03295_
+ sky130_fd_sc_hd__o22ai_1
X_06621_ _03283_ _03292_ _03295_ VSS VSS VDD VDD _03296_ sky130_fd_sc_hd__a21oi_1
X_06622_ _02938_ _02946_ _03296_ VSS VSS VDD VDD _03297_ sky130_fd_sc_hd__a21o_1
X_06623_ _00537_ _01846_ VSS VSS VDD VDD _03298_ sky130_fd_sc_hd__nor2b_1
X_06624_ _01845_ _03298_ _01842_ VSS VSS VDD VDD _03299_ sky130_fd_sc_hd__o21ai_0
X_06625_ _01837_ _01841_ VSS VSS VDD VDD _03300_ sky130_fd_sc_hd__nor2_1
X_06626_ _01842_ _01841_ _01837_ VSS VSS VDD VDD _03301_ sky130_fd_sc_hd__o21a_1
X_06627_ _01841_ _01845_ _03298_ _03301_ VSS VSS VDD VDD _03302_
+ sky130_fd_sc_hd__o31a_1
X_06628_ _03299_ _03300_ _03302_ VSS VSS VDD VDD _03303_ sky130_fd_sc_hd__a21oi_1
X_06629_ _02938_ _02946_ _03296_ _03303_ VSS VSS VDD VDD _03304_
+ sky130_fd_sc_hd__a31o_1
X_06630_ _01854_ _03297_ _03304_ _01853_ VSS VSS VDD VDD _03305_
+ sky130_fd_sc_hd__a31o_2
X_06631_ _01836_ _03302_ _01833_ VSS VSS VDD VDD _03306_ sky130_fd_sc_hd__o21a_1
X_06632_ _01832_ _03306_ VSS VSS VDD VDD _03307_ sky130_fd_sc_hd__nor2_1
X_06633_ _01826_ _03307_ VSS VSS VDD VDD _03308_ sky130_fd_sc_hd__xnor2_1
X_06634_ _01594_ _03308_ VSS VSS VDD VDD _03309_ sky130_fd_sc_hd__xor2_1
X_06635_ _03305_ _03309_ VSS VSS VDD VDD _01095_ sky130_fd_sc_hd__xor2_1
X_06636_ _01095_ VSS VSS VDD VDD _01104_ sky130_fd_sc_hd__inv_1
X_06637_ stage3_in_r\[192\] VSS VSS VDD VDD _03310_ sky130_fd_sc_hd__inv_1
X_06638_ _01854_ _03297_ _03304_ VSS VSS VDD VDD _03311_ sky130_fd_sc_hd__nand3_1
X_06639_ _03297_ _03304_ _01854_ VSS VSS VDD VDD _03312_ sky130_fd_sc_hd__a21o_1
X_06640_ _03310_ _03311_ _03312_ VSS VSS VDD VDD _01094_ sky130_fd_sc_hd__and3_1
X_06641_ _00548_ VSS VSS VDD VDD _00545_ sky130_fd_sc_hd__inv_1
X_06642_ _01594_ _03308_ VSS VSS VDD VDD _03313_ sky130_fd_sc_hd__and2_1
X_06643_ _03305_ _03309_ _03313_ VSS VSS VDD VDD _03314_ sky130_fd_sc_hd__a21o_1
X_06644_ _01833_ _01832_ _01826_ VSS VSS VDD VDD _03315_ sky130_fd_sc_hd__o21a_1
X_06645_ _01825_ _03315_ VSS VSS VDD VDD _03316_ sky130_fd_sc_hd__nor2_1
X_06646_ _01842_ VSS VSS VDD VDD _03317_ sky130_fd_sc_hd__inv_1
X_06647_ _01861_ _01850_ _01849_ VSS VSS VDD VDD _03318_ sky130_fd_sc_hd__a21o_1
X_06648_ _01846_ _03318_ _01845_ VSS VSS VDD VDD _03319_ sky130_fd_sc_hd__a21oi_1
X_06649_ _03317_ _03319_ _01841_ VSS VSS VDD VDD _03320_ sky130_fd_sc_hd__o21bai_1
X_06650_ _01825_ _01832_ _01836_ VSS VSS VDD VDD _03321_ sky130_fd_sc_hd__or3_1
X_06651_ _01837_ _03320_ _03321_ VSS VSS VDD VDD _03322_ sky130_fd_sc_hd__a21oi_1
X_06652_ _03316_ _03322_ _01887_ VSS VSS VDD VDD _03323_ sky130_fd_sc_hd__o21ai_0
X_06653_ _01887_ _03316_ _03322_ VSS VSS VDD VDD _03324_ sky130_fd_sc_hd__or3_1
X_06654_ _03323_ _03324_ VSS VSS VDD VDD _03325_ sky130_fd_sc_hd__nand2_1
X_06655_ net423 _03325_ VSS VSS VDD VDD _03326_ sky130_fd_sc_hd__xor2_1
X_06656_ _03314_ _03326_ VSS VSS VDD VDD _01972_ sky130_fd_sc_hd__xor2_1
X_06657_ _01972_ VSS VSS VDD VDD _01975_ sky130_fd_sc_hd__inv_1
X_06658_ _00557_ VSS VSS VDD VDD _00554_ sky130_fd_sc_hd__inv_1
X_06659_ net423 _03314_ _03325_ VSS VSS VDD VDD _03327_ sky130_fd_sc_hd__maj3_1
X_06660_ _01886_ VSS VSS VDD VDD _03328_ sky130_fd_sc_hd__inv_1
X_06661_ _03321_ _03328_ VSS VSS VDD VDD _03329_ sky130_fd_sc_hd__nand2b_1
X_06662_ _01833_ _01825_ _01832_ VSS VSS VDD VDD _03330_ sky130_fd_sc_hd__nor3_1
X_06663_ _01826_ _01825_ _01887_ VSS VSS VDD VDD _03331_ sky130_fd_sc_hd__o21ai_0
X_06664_ _03330_ _03331_ _03328_ VSS VSS VDD VDD _03332_ sky130_fd_sc_hd__o21ai_0
X_06665_ _03302_ _03329_ _03332_ VSS VSS VDD VDD _03333_ sky130_fd_sc_hd__o21ai_0
X_06666_ _01892_ _03333_ VSS VSS VDD VDD _03334_ sky130_fd_sc_hd__xnor2_1
X_06667_ _03028_ _03029_ _03032_ _03334_ _03035_ VSS VSS VDD
+ VDD _03335_ sky130_fd_sc_hd__o2111ai_1
X_06668_ _03031_ _03034_ _03334_ _03030_ _01308_ VSS VSS VDD
+ VDD _03336_ sky130_fd_sc_hd__o2111ai_1
X_06669_ _03335_ _03336_ VSS VSS VDD VDD _03337_ sky130_fd_sc_hd__nand2_1
X_06670_ _03033_ _03036_ _03334_ VSS VSS VDD VDD _03338_ sky130_fd_sc_hd__a21o_1
X_06671_ _03337_ _03338_ VSS VSS VDD VDD _03339_ sky130_fd_sc_hd__nor2b_1
X_06672_ _03327_ _03339_ VSS VSS VDD VDD _01977_ sky130_fd_sc_hd__xor2_1
X_06673_ _01977_ VSS VSS VDD VDD _01980_ sky130_fd_sc_hd__inv_1
X_06674_ _00568_ VSS VSS VDD VDD _00565_ sky130_fd_sc_hd__inv_1
X_06675_ _03323_ _03324_ _03335_ _03336_ VSS VSS VDD VDD _03340_
+ sky130_fd_sc_hd__nand4_1
X_06676_ _01669_ _03340_ _03338_ VSS VSS VDD VDD _03341_ sky130_fd_sc_hd__o21ai_0
X_06677_ _03305_ _03309_ _03313_ _03340_ VSS VSS VDD VDD _03342_
+ sky130_fd_sc_hd__a211oi_1
X_06678_ _03305_ _03309_ _03313_ _03337_ net423 VSS VSS VDD
+ VDD _03343_ sky130_fd_sc_hd__a2111oi_4
X_06679_ _03341_ _03342_ _03343_ VSS VSS VDD VDD _03344_ sky130_fd_sc_hd__nor3_2
X_06680_ _01897_ VSS VSS VDD VDD _03345_ sky130_fd_sc_hd__inv_1
X_06681_ _01837_ _03320_ _03321_ _01891_ _01886_ VSS VSS VDD
+ VDD _03346_ sky130_fd_sc_hd__a2111oi_0
X_06682_ _01892_ _03332_ _01891_ VSS VSS VDD VDD _03347_ sky130_fd_sc_hd__a21oi_1
X_06683_ _03346_ _03347_ VSS VSS VDD VDD _03348_ sky130_fd_sc_hd__nor2_1
X_06684_ _03345_ _03348_ VSS VSS VDD VDD _03349_ sky130_fd_sc_hd__xnor2_1
X_06685_ _01681_ _03349_ VSS VSS VDD VDD _03350_ sky130_fd_sc_hd__xnor2_1
X_06686_ _03344_ _03350_ VSS VSS VDD VDD _01982_ sky130_fd_sc_hd__xnor2_1
X_06687_ _01982_ VSS VSS VDD VDD _01985_ sky130_fd_sc_hd__inv_1
X_06688_ _01681_ VSS VSS VDD VDD _03351_ sky130_fd_sc_hd__inv_1
X_06689_ _03344_ _03349_ VSS VSS VDD VDD _03352_ sky130_fd_sc_hd__nor2_1
X_06690_ _03351_ _03352_ VSS VSS VDD VDD _03353_ sky130_fd_sc_hd__nor2_1
X_06691_ _03344_ _03349_ _03353_ VSS VSS VDD VDD _03354_ sky130_fd_sc_hd__a21oi_2
X_06692_ _01896_ VSS VSS VDD VDD _03355_ sky130_fd_sc_hd__inv_1
X_06693_ _03302_ _03329_ _03332_ _01892_ VSS VSS VDD VDD _03356_
+ sky130_fd_sc_hd__o211a_1
X_06694_ _01891_ _03356_ _01897_ VSS VSS VDD VDD _03357_ sky130_fd_sc_hd__o21ai_0
X_06695_ _03355_ _03357_ _01901_ VSS VSS VDD VDD _03358_ sky130_fd_sc_hd__a21boi_1
X_06696_ _01901_ _01896_ _03357_ VSS VSS VDD VDD _03359_ sky130_fd_sc_hd__nor3b_1
X_06697_ _03358_ _03359_ VSS VSS VDD VDD _03360_ sky130_fd_sc_hd__nor2_1
X_06698_ net422 _03360_ VSS VSS VDD VDD _03361_ sky130_fd_sc_hd__xnor2_1
X_06699_ _03354_ _03361_ VSS VSS VDD VDD _01902_ sky130_fd_sc_hd__xor2_1
X_06700_ _01902_ VSS VSS VDD VDD _01905_ sky130_fd_sc_hd__inv_1
X_06701_ net422 _03360_ VSS VSS VDD VDD _03362_ sky130_fd_sc_hd__nand2_1
X_06702_ net422 _03360_ VSS VSS VDD VDD _03363_ sky130_fd_sc_hd__nor2_1
X_06703_ _03354_ _03362_ _03363_ VSS VSS VDD VDD _03364_ sky130_fd_sc_hd__a21oi_1
X_06704_ _01909_ VSS VSS VDD VDD _03365_ sky130_fd_sc_hd__inv_1
X_06705_ _03345_ _03346_ _03347_ _03355_ VSS VSS VDD VDD _03366_
+ sky130_fd_sc_hd__o31ai_1
X_06706_ _01901_ _03366_ _01900_ VSS VSS VDD VDD _03367_ sky130_fd_sc_hd__a21oi_1
X_06707_ _03365_ _03367_ VSS VSS VDD VDD _03368_ sky130_fd_sc_hd__xnor2_1
X_06708_ net420 _03368_ VSS VSS VDD VDD _03369_ sky130_fd_sc_hd__xnor2_1
X_06709_ _03364_ _03369_ VSS VSS VDD VDD _01910_ sky130_fd_sc_hd__xnor2_1
X_06710_ _01910_ VSS VSS VDD VDD _01913_ sky130_fd_sc_hd__inv_1
X_06711_ _03349_ VSS VSS VDD VDD _03370_ sky130_fd_sc_hd__inv_1
X_06712_ _03351_ _03370_ _03368_ net420 _03362_ VSS VSS VDD
+ VDD _03371_ sky130_fd_sc_hd__o221ai_1
X_06713_ net422 _03360_ _03349_ _01681_ VSS VSS VDD VDD _03372_
+ sky130_fd_sc_hd__a211oi_1
X_06714_ net420 _03368_ _03372_ _03363_ VSS VSS VDD VDD _03373_
+ sky130_fd_sc_hd__o22ai_1
X_06715_ net420 _03368_ VSS VSS VDD VDD _03374_ sky130_fd_sc_hd__nand2_1
X_06716_ _03344_ _03371_ _03373_ _03374_ VSS VSS VDD VDD _03375_
+ sky130_fd_sc_hd__o211a_1
X_06717_ _01900_ _03358_ _01909_ VSS VSS VDD VDD _03376_ sky130_fd_sc_hd__o21a_1
X_06718_ _01908_ _03376_ VSS VSS VDD VDD _03377_ sky130_fd_sc_hd__nor2_1
X_06719_ _01919_ _03377_ VSS VSS VDD VDD _03378_ sky130_fd_sc_hd__xnor2_1
X_06720_ _01709_ _03378_ VSS VSS VDD VDD _03379_ sky130_fd_sc_hd__xnor2_1
X_06721_ _03375_ _03379_ VSS VSS VDD VDD _01920_ sky130_fd_sc_hd__xnor2_1
X_06722_ _01920_ VSS VSS VDD VDD _01923_ sky130_fd_sc_hd__inv_1
X_06723_ _01709_ _03375_ _03378_ VSS VSS VDD VDD _03380_ sky130_fd_sc_hd__maj3_1
X_06724_ _01930_ VSS VSS VDD VDD _03381_ sky130_fd_sc_hd__inv_1
X_06725_ _03381_ _01908_ _01918_ VSS VSS VDD VDD _03382_ sky130_fd_sc_hd__nor3_1
X_06726_ _03365_ _03367_ _03382_ VSS VSS VDD VDD _03383_ sky130_fd_sc_hd__o21ai_0
X_06727_ _01930_ _01919_ VSS VSS VDD VDD _03384_ sky130_fd_sc_hd__nor2b_1
X_06728_ _03367_ _03384_ _01909_ VSS VSS VDD VDD _03385_ sky130_fd_sc_hd__nand3b_1
X_06729_ _01919_ _03381_ _01918_ VSS VSS VDD VDD _03386_ sky130_fd_sc_hd__nor3_1
X_06730_ _03381_ _01918_ _03384_ _01908_ _03386_ VSS VSS VDD
+ VDD _03387_ sky130_fd_sc_hd__a221oi_1
X_06731_ _03383_ _03385_ _03387_ VSS VSS VDD VDD _03388_ sky130_fd_sc_hd__nand3_1
X_06732_ _01720_ _03388_ VSS VSS VDD VDD _03389_ sky130_fd_sc_hd__xnor2_1
X_06733_ _03380_ _03389_ VSS VSS VDD VDD _01931_ sky130_fd_sc_hd__xnor2_1
X_06734_ _01931_ VSS VSS VDD VDD _01934_ sky130_fd_sc_hd__inv_1
X_06735_ _01720_ _03388_ VSS VSS VDD VDD _03390_ sky130_fd_sc_hd__nor2_1
X_06736_ _01709_ _03378_ _03388_ _01720_ VSS VSS VDD VDD _03391_
+ sky130_fd_sc_hd__a22oi_1
X_06737_ _01709_ _03378_ _03388_ _01720_ VSS VSS VDD VDD _03392_
+ sky130_fd_sc_hd__o22ai_1
X_06738_ _03344_ _03371_ _03373_ _03374_ VSS VSS VDD VDD _03393_
+ sky130_fd_sc_hd__o211ai_1
X_06739_ _03390_ _03391_ _03392_ _03393_ VSS VSS VDD VDD _03394_
+ sky130_fd_sc_hd__o22a_2
X_06740_ _01919_ _01908_ _01918_ VSS VSS VDD VDD _03395_ sky130_fd_sc_hd__a21oi_1
X_06741_ _01900_ _03358_ _01909_ _01919_ VSS VSS VDD VDD _03396_
+ sky130_fd_sc_hd__o211ai_1
X_06742_ _03395_ _03396_ _03381_ VSS VSS VDD VDD _03397_ sky130_fd_sc_hd__a21oi_1
X_06743_ _01929_ _03397_ VSS VSS VDD VDD _03398_ sky130_fd_sc_hd__nor2_1
X_06744_ _01943_ _03398_ VSS VSS VDD VDD _03399_ sky130_fd_sc_hd__xor2_1
X_06745_ _01731_ _03399_ VSS VSS VDD VDD _03400_ sky130_fd_sc_hd__xnor2_1
X_06746_ _03394_ _03400_ VSS VSS VDD VDD _01987_ sky130_fd_sc_hd__xnor2_1
X_06747_ _01987_ VSS VSS VDD VDD _01990_ sky130_fd_sc_hd__inv_1
X_06748_ net419 _03394_ _03399_ VSS VSS VDD VDD _03401_ sky130_fd_sc_hd__maj3_1
X_06749_ _01909_ _01919_ _01930_ _01943_ VSS VSS VDD VDD _03402_
+ sky130_fd_sc_hd__nand4_1
X_06750_ _03381_ _03395_ _01929_ VSS VSS VDD VDD _03403_ sky130_fd_sc_hd__o21bai_1
X_06751_ _01943_ _03403_ _01942_ VSS VSS VDD VDD _03404_ sky130_fd_sc_hd__a21oi_1
X_06752_ _03367_ _03402_ _03404_ VSS VSS VDD VDD _03405_ sky130_fd_sc_hd__o21ai_0
X_06753_ _01948_ _03405_ VSS VSS VDD VDD _03406_ sky130_fd_sc_hd__xor2_1
X_06754_ _01737_ _03406_ VSS VSS VDD VDD _03407_ sky130_fd_sc_hd__xnor2_1
X_06755_ _03401_ _03407_ VSS VSS VDD VDD _01992_ sky130_fd_sc_hd__xor2_1
X_06756_ _01992_ VSS VSS VDD VDD _01995_ sky130_fd_sc_hd__inv_1
X_06757_ _01900_ _03358_ _03402_ VSS VSS VDD VDD _03408_ sky130_fd_sc_hd__o21bai_1
X_06758_ _03408_ _03404_ _01948_ VSS VSS VDD VDD _03409_ sky130_fd_sc_hd__a21boi_0
X_06759_ _01947_ _03409_ _01950_ VSS VSS VDD VDD _03410_ sky130_fd_sc_hd__o21a_1
X_06760_ _01950_ _01947_ _03409_ VSS VSS VDD VDD _03411_ sky130_fd_sc_hd__nor3_1
X_06761_ _03410_ _03411_ VSS VSS VDD VDD _03412_ sky130_fd_sc_hd__nor2_1
X_06762_ net417 _03412_ VSS VSS VDD VDD _03413_ sky130_fd_sc_hd__xor2_1
X_06763_ _01737_ _03406_ VSS VSS VDD VDD _03414_ sky130_fd_sc_hd__nand2_1
X_06764_ net419 _03399_ _03406_ _01737_ VSS VSS VDD VDD _03415_
+ sky130_fd_sc_hd__o2bb2ai_1
X_06765_ net419 _03399_ _03406_ _01737_ VSS VSS VDD VDD _03416_
+ sky130_fd_sc_hd__a2bb2oi_1
X_06766_ _03414_ _03415_ _03416_ _03394_ VSS VSS VDD VDD _03417_
+ sky130_fd_sc_hd__a22oi_2
X_06767_ _03413_ _03417_ VSS VSS VDD VDD _01997_ sky130_fd_sc_hd__xor2_1
X_06768_ _01997_ VSS VSS VDD VDD _02000_ sky130_fd_sc_hd__inv_1
X_06769_ net417 _03412_ _03417_ VSS VSS VDD VDD _03418_ sky130_fd_sc_hd__maj3_2
X_06770_ _01948_ _03405_ _01947_ VSS VSS VDD VDD _03419_ sky130_fd_sc_hd__a21o_1
X_06771_ _01950_ _03419_ _01949_ VSS VSS VDD VDD _03420_ sky130_fd_sc_hd__a21oi_1
X_06772_ _01952_ _03420_ VSS VSS VDD VDD _03421_ sky130_fd_sc_hd__xnor2_1
X_06773_ net416 _03421_ VSS VSS VDD VDD _03422_ sky130_fd_sc_hd__xnor2_1
X_06774_ _03418_ _03422_ VSS VSS VDD VDD _02002_ sky130_fd_sc_hd__xnor2_1
X_06775_ _02002_ VSS VSS VDD VDD _02005_ sky130_fd_sc_hd__inv_1
X_06776_ net416 _03418_ _03421_ VSS VSS VDD VDD _03423_ sky130_fd_sc_hd__maj3_2
X_06777_ _01959_ _03423_ VSS VSS VDD VDD _02007_ sky130_fd_sc_hd__xor2_1
X_06778_ _02007_ VSS VSS VDD VDD _02010_ sky130_fd_sc_hd__inv_1
X_06779_ _01959_ _03423_ _01958_ VSS VSS VDD VDD _03424_ sky130_fd_sc_hd__a21o_1
X_06780_ _01965_ _03424_ VSS VSS VDD VDD _02015_ sky130_fd_sc_hd__xnor2_1
X_06781_ net446 VSS VSS VDD VDD _03425_ sky130_fd_sc_hd__inv_1
Xinput133 in_flat[75] VSS VSS VDD VDD net132 sky130_fd_sc_hd__clkdlybuf4s50_1
X_06783_ _01949_ _03410_ _01952_ VSS VSS VDD VDD _03426_ sky130_fd_sc_hd__o21ai_0
X_06784_ _01951_ _03426_ VSS VSS VDD VDD _03427_ sky130_fd_sc_hd__nand2b_1
X_06785_ _01956_ _03427_ _01955_ VSS VSS VDD VDD _03428_ sky130_fd_sc_hd__a21o_1
X_06786_ _01962_ _03428_ _01961_ VSS VSS VDD VDD _03429_ sky130_fd_sc_hd__a21oi_1
X_06787_ net427 _03429_ VSS VSS VDD VDD _03430_ sky130_fd_sc_hd__xnor2_1
X_06788_ net414 _03430_ VSS VSS VDD VDD _03431_ sky130_fd_sc_hd__xnor2_1
X_06789_ net416 _03421_ VSS VSS VDD VDD _03432_ sky130_fd_sc_hd__or2_2
X_06790_ net416 _03421_ _01958_ _01964_ VSS VSS VDD VDD _03433_
+ sky130_fd_sc_hd__a211o_1
X_06791_ _03418_ _03432_ _03433_ VSS VSS VDD VDD _03434_ sky130_fd_sc_hd__a21oi_1
X_06792_ _01959_ _01958_ _01964_ VSS VSS VDD VDD _03435_ sky130_fd_sc_hd__nor3_1
X_06793_ _01965_ _01964_ VSS VSS VDD VDD _03436_ sky130_fd_sc_hd__nor2_1
X_06794_ _03434_ _03435_ _03436_ VSS VSS VDD VDD _03437_ sky130_fd_sc_hd__or3_1
X_06795_ _03431_ _03437_ VSS VSS VDD VDD _02018_ sky130_fd_sc_hd__xnor2_1
Xinput132 in_flat[74] VSS VSS VDD VDD net131 sky130_fd_sc_hd__clkdlybuf4s50_1
X_06797_ net447 _00590_ VSS VSS VDD VDD _00685_ sky130_fd_sc_hd__xnor2_1
X_06798_ _02085_ VSS VSS VDD VDD _03439_ sky130_fd_sc_hd__inv_1
X_06799_ _02094_ VSS VSS VDD VDD _03440_ sky130_fd_sc_hd__inv_1
X_06800_ _02109_ VSS VSS VDD VDD _03441_ sky130_fd_sc_hd__inv_1
X_06801_ _00823_ _02113_ VSS VSS VDD VDD _03442_ sky130_fd_sc_hd__nor2b_1
X_06802_ _02112_ _03442_ _02110_ VSS VSS VDD VDD _03443_ sky130_fd_sc_hd__o21ai_0
X_06803_ _03441_ _03443_ _02102_ VSS VSS VDD VDD _03444_ sky130_fd_sc_hd__a21boi_0
X_06804_ _02101_ _03444_ _02095_ VSS VSS VDD VDD _03445_ sky130_fd_sc_hd__o21ai_0
X_06805_ _03440_ _03445_ _02092_ VSS VSS VDD VDD _03446_ sky130_fd_sc_hd__a21boi_0
X_06806_ _02091_ _03446_ _02086_ VSS VSS VDD VDD _03447_ sky130_fd_sc_hd__o21ai_0
X_06807_ _03439_ _03447_ _02078_ VSS VSS VDD VDD _03448_ sky130_fd_sc_hd__a21boi_0
X_06808_ _02077_ _03448_ _02074_ VSS VSS VDD VDD _03449_ sky130_fd_sc_hd__o21a_1
X_06809_ _02073_ _03449_ VSS VSS VDD VDD _03450_ sky130_fd_sc_hd__nor2_1
X_06810_ _02083_ _03450_ VSS VSS VDD VDD _02122_ sky130_fd_sc_hd__xor2_1
X_06811_ _02086_ VSS VSS VDD VDD _03451_ sky130_fd_sc_hd__inv_1
X_06812_ _02095_ VSS VSS VDD VDD _03452_ sky130_fd_sc_hd__inv_1
X_06813_ _02110_ VSS VSS VDD VDD _03453_ sky130_fd_sc_hd__inv_1
X_06814_ _02155_ _02117_ _02116_ VSS VSS VDD VDD _03454_ sky130_fd_sc_hd__a21o_1
X_06815_ _02113_ _03454_ _02112_ VSS VSS VDD VDD _03455_ sky130_fd_sc_hd__a21oi_1
X_06816_ _03453_ _03455_ _03441_ VSS VSS VDD VDD _03456_ sky130_fd_sc_hd__o21ai_0
X_06817_ _02102_ _03456_ _02101_ VSS VSS VDD VDD _03457_ sky130_fd_sc_hd__a21oi_1
X_06818_ _03452_ _03457_ _03440_ VSS VSS VDD VDD _03458_ sky130_fd_sc_hd__o21ai_0
X_06819_ _02092_ _03458_ _02091_ VSS VSS VDD VDD _03459_ sky130_fd_sc_hd__a21oi_1
X_06820_ _03451_ _03459_ _03439_ VSS VSS VDD VDD _03460_ sky130_fd_sc_hd__o21ai_0
X_06821_ _02078_ _03460_ _02077_ VSS VSS VDD VDD _03461_ sky130_fd_sc_hd__a21oi_1
X_06822_ _02074_ _03461_ VSS VSS VDD VDD _02126_ sky130_fd_sc_hd__xor2_1
X_06823_ _03439_ _03447_ VSS VSS VDD VDD _03462_ sky130_fd_sc_hd__nand2_1
X_06824_ _02078_ _03462_ VSS VSS VDD VDD _02130_ sky130_fd_sc_hd__xnor2_1
X_06825_ _03451_ _03459_ VSS VSS VDD VDD _02134_ sky130_fd_sc_hd__xnor2_1
X_06826_ _03440_ _03445_ VSS VSS VDD VDD _03463_ sky130_fd_sc_hd__nand2_1
X_06827_ _02092_ _03463_ VSS VSS VDD VDD _02139_ sky130_fd_sc_hd__xnor2_1
X_06828_ _03452_ _03457_ VSS VSS VDD VDD _02143_ sky130_fd_sc_hd__xnor2_1
X_06829_ _03441_ _03443_ VSS VSS VDD VDD _03464_ sky130_fd_sc_hd__nand2_1
X_06830_ _02102_ _03464_ VSS VSS VDD VDD _02146_ sky130_fd_sc_hd__xnor2_1
X_06831_ _03453_ _03455_ VSS VSS VDD VDD _02149_ sky130_fd_sc_hd__xnor2_1
X_06832_ _00823_ _02113_ VSS VSS VDD VDD _02152_ sky130_fd_sc_hd__xor2_1
X_06833_ _02157_ _02161_ VSS VSS VDD VDD _03465_ sky130_fd_sc_hd__nand2_1
X_06834_ net445 net457 VSS VSS VDD VDD _03466_ sky130_fd_sc_hd__nand2b_1
X_06835_ _02171_ _03466_ _02170_ VSS VSS VDD VDD _03467_ sky130_fd_sc_hd__a21o_1
X_06836_ _02168_ _03467_ _02167_ VSS VSS VDD VDD _03468_ sky130_fd_sc_hd__a21o_1
X_06837_ _02165_ _03468_ _02164_ VSS VSS VDD VDD _03469_ sky130_fd_sc_hd__a21oi_1
X_06838_ _02148_ _02150_ _02160_ _02157_ VSS VSS VDD VDD _03470_
+ sky130_fd_sc_hd__a22o_1
X_06839_ _02147_ _02153_ _02156_ _03470_ VSS VSS VDD VDD _03471_
+ sky130_fd_sc_hd__nor4_1
X_06840_ _03465_ _03469_ _03471_ VSS VSS VDD VDD _03472_ sky130_fd_sc_hd__o21ai_0
X_06841_ _02154_ _02153_ _02151_ VSS VSS VDD VDD _03473_ sky130_fd_sc_hd__o21a_1
X_06842_ _02150_ _03473_ _02148_ VSS VSS VDD VDD _03474_ sky130_fd_sc_hd__o21ai_0
X_06843_ _02147_ _03474_ VSS VSS VDD VDD _03475_ sky130_fd_sc_hd__nand2b_1
X_06844_ _02145_ _03472_ _03475_ _02144_ VSS VSS VDD VDD _03476_
+ sky130_fd_sc_hd__a31o_2
X_06845_ _02142_ _03476_ _02141_ VSS VSS VDD VDD _03477_ sky130_fd_sc_hd__a21o_1
X_06846_ _02129_ _02128_ _03477_ _02133_ _02137_ VSS VSS VDD
+ VDD _03478_ sky130_fd_sc_hd__o2111ai_1
X_06847_ _02133_ _02136_ _02132_ VSS VSS VDD VDD _03479_ sky130_fd_sc_hd__a21o_1
X_06848_ _02129_ _03479_ _02128_ VSS VSS VDD VDD _03480_ sky130_fd_sc_hd__a21oi_1
X_06849_ _03478_ _03480_ VSS VSS VDD VDD _03481_ sky130_fd_sc_hd__nand2_1
X_06850_ _02125_ _03481_ _02124_ VSS VSS VDD VDD _03482_ sky130_fd_sc_hd__a21oi_1
X_06851_ _02121_ _03482_ VSS VSS VDD VDD _01100_ sky130_fd_sc_hd__xnor2_1
X_06852_ _01100_ VSS VSS VDD VDD _01108_ sky130_fd_sc_hd__inv_1
X_06853_ net458 _02125_ VSS VSS VDD VDD _03483_ sky130_fd_sc_hd__nor2b_1
X_06854_ net458 _02125_ VSS VSS VDD VDD _03484_ sky130_fd_sc_hd__nor2_1
X_06855_ _03483_ _03484_ _03481_ VSS VSS VDD VDD _01099_ sky130_fd_sc_hd__mux2_2
X_06856_ _00832_ VSS VSS VDD VDD _00829_ sky130_fd_sc_hd__inv_1
X_06857_ _02385_ _01926_ VSS VSS VDD VDD _02178_ sky130_fd_sc_hd__or2_2
X_06858_ _02178_ VSS VSS VDD VDD _02229_ sky130_fd_sc_hd__inv_1
X_06859_ _00846_ VSS VSS VDD VDD _00843_ sky130_fd_sc_hd__inv_1
X_06860_ _02125_ _02121_ VSS VSS VDD VDD _03485_ sky130_fd_sc_hd__nand2_1
X_06861_ _03480_ _03485_ VSS VSS VDD VDD _03486_ sky130_fd_sc_hd__nor2_1
X_06862_ _02121_ _02124_ _03486_ VSS VSS VDD VDD _03487_ sky130_fd_sc_hd__a21oi_1
X_06863_ _03478_ _03485_ _03487_ VSS VSS VDD VDD _03488_ sky130_fd_sc_hd__o21a_1
X_06864_ _02120_ _03488_ VSS VSS VDD VDD _03489_ sky130_fd_sc_hd__nor2b_2
X_06865_ _02187_ _03489_ VSS VSS VDD VDD _02420_ sky130_fd_sc_hd__xnor2_1
X_06866_ _02420_ VSS VSS VDD VDD _02423_ sky130_fd_sc_hd__inv_1
X_06867_ _00855_ VSS VSS VDD VDD _00852_ sky130_fd_sc_hd__inv_1
X_06868_ _00688_ VSS VSS VDD VDD _00722_ sky130_fd_sc_hd__inv_1
X_06869_ _00861_ _00688_ VSS VSS VDD VDD _03490_ sky130_fd_sc_hd__xor2_1
X_06870_ net447 _03490_ VSS VSS VDD VDD _02193_ sky130_fd_sc_hd__xnor2_1
X_06871_ _00869_ VSS VSS VDD VDD _00866_ sky130_fd_sc_hd__inv_1
X_06872_ _03489_ VSS VSS VDD VDD _03491_ sky130_fd_sc_hd__inv_1
X_06873_ _02187_ _03491_ _02186_ VSS VSS VDD VDD _03492_ sky130_fd_sc_hd__a21oi_1
X_06874_ _02205_ _03492_ VSS VSS VDD VDD _02425_ sky130_fd_sc_hd__xnor2_1
X_06875_ _02425_ VSS VSS VDD VDD _02428_ sky130_fd_sc_hd__inv_1
X_06876_ _00880_ VSS VSS VDD VDD _00877_ sky130_fd_sc_hd__inv_1
X_06877_ net427 _03490_ _00835_ VSS VSS VDD VDD _00887_ sky130_fd_sc_hd__mux2_2
X_06878_ _00891_ VSS VSS VDD VDD _00888_ sky130_fd_sc_hd__inv_1
X_06879_ _02120_ _02186_ _02204_ VSS VSS VDD VDD _03493_ sky130_fd_sc_hd__nor3_1
X_06880_ _02187_ _02186_ _02205_ VSS VSS VDD VDD _03494_ sky130_fd_sc_hd__o21a_1
X_06881_ _02204_ _03494_ VSS VSS VDD VDD _03495_ sky130_fd_sc_hd__nor2_1
X_06882_ _03488_ _03493_ _03495_ VSS VSS VDD VDD _03496_ sky130_fd_sc_hd__a21oi_1
X_06883_ _02221_ _03496_ VSS VSS VDD VDD _02430_ sky130_fd_sc_hd__xor2_1
X_06884_ _02430_ VSS VSS VDD VDD _02433_ sky130_fd_sc_hd__inv_1
X_06885_ net447 _02228_ VSS VSS VDD VDD _02232_ sky130_fd_sc_hd__xor2_1
X_06886_ _00590_ _00860_ VSS VSS VDD VDD _03497_ sky130_fd_sc_hd__xnor2_1
X_06887_ _01937_ _00722_ _03497_ VSS VSS VDD VDD _03498_ sky130_fd_sc_hd__a21oi_1
X_06888_ _01937_ _00688_ VSS VSS VDD VDD _03499_ sky130_fd_sc_hd__nand2_1
X_06889_ net447 _03497_ _03499_ VSS VSS VDD VDD _03500_ sky130_fd_sc_hd__or3_1
X_06890_ net427 _03498_ _03500_ VSS VSS VDD VDD _00908_ sky130_fd_sc_hd__o21a_1
X_06891_ net447 _02194_ VSS VSS VDD VDD _00909_ sky130_fd_sc_hd__nand2_1
X_06892_ _02221_ _03496_ _02220_ VSS VSS VDD VDD _03501_ sky130_fd_sc_hd__a21oi_1
X_06893_ _02242_ _03501_ VSS VSS VDD VDD _02243_ sky130_fd_sc_hd__xnor2_1
X_06894_ _02243_ VSS VSS VDD VDD _02246_ sky130_fd_sc_hd__inv_1
X_06895_ _02210_ VSS VSS VDD VDD _03502_ sky130_fd_sc_hd__inv_1
X_06896_ _02176_ VSS VSS VDD VDD _03503_ sky130_fd_sc_hd__inv_1
X_06897_ _02037_ VSS VSS VDD VDD _03504_ sky130_fd_sc_hd__inv_1
X_06898_ _02044_ VSS VSS VDD VDD _03505_ sky130_fd_sc_hd__inv_1
X_06899_ _02138_ _02051_ _02050_ VSS VSS VDD VDD _03506_ sky130_fd_sc_hd__a21o_1
X_06900_ _02047_ _03506_ _02046_ VSS VSS VDD VDD _03507_ sky130_fd_sc_hd__a21oi_1
X_06901_ _02043_ VSS VSS VDD VDD _03508_ sky130_fd_sc_hd__inv_1
X_06902_ _03505_ _03507_ _03508_ VSS VSS VDD VDD _03509_ sky130_fd_sc_hd__o21ai_0
X_06903_ _02041_ _03509_ _02040_ VSS VSS VDD VDD _03510_ sky130_fd_sc_hd__a21oi_1
X_06904_ _02036_ VSS VSS VDD VDD _03511_ sky130_fd_sc_hd__inv_1
X_06905_ _03504_ _03510_ _03511_ VSS VSS VDD VDD _03512_ sky130_fd_sc_hd__o21ai_0
X_06906_ _02032_ _03512_ _02031_ VSS VSS VDD VDD _03513_ sky130_fd_sc_hd__a21oi_1
X_06907_ _02175_ VSS VSS VDD VDD _03514_ sky130_fd_sc_hd__inv_1
X_06908_ _03503_ _03513_ _03514_ VSS VSS VDD VDD _03515_ sky130_fd_sc_hd__o21ai_0
X_06909_ _02192_ _03515_ _02191_ VSS VSS VDD VDD _03516_ sky130_fd_sc_hd__a21oi_1
X_06910_ _03502_ _03516_ _02209_ VSS VSS VDD VDD _03517_ sky130_fd_sc_hd__o21bai_1
X_06911_ _02226_ _03517_ _02225_ VSS VSS VDD VDD _03518_ sky130_fd_sc_hd__a21o_1
X_06912_ _02253_ _03518_ VSS VSS VDD VDD _02264_ sky130_fd_sc_hd__xor2_1
X_06913_ _02230_ _02227_ VSS VSS VDD VDD _02255_ sky130_fd_sc_hd__or2_2
X_06914_ _02255_ VSS VSS VDD VDD _02257_ sky130_fd_sc_hd__inv_1
X_06915_ _02228_ net447 _00860_ VSS VSS VDD VDD _00929_ sky130_fd_sc_hd__mux2i_1
X_06916_ net447 _02212_ VSS VSS VDD VDD _00930_ sky130_fd_sc_hd__nand2_1
X_06917_ _02073_ _03449_ _02083_ VSS VSS VDD VDD _03519_ sky130_fd_sc_hd__o21ai_0
X_06918_ _02066_ _02082_ VSS VSS VDD VDD _03520_ sky130_fd_sc_hd__nor2_1
X_06919_ _02067_ _02066_ VSS VSS VDD VDD _03521_ sky130_fd_sc_hd__nor2_1
X_06920_ _02183_ _02201_ _02217_ VSS VSS VDD VDD _03522_ sky130_fd_sc_hd__nand3_1
X_06921_ _03519_ _03520_ _03521_ _03522_ VSS VSS VDD VDD _03523_
+ sky130_fd_sc_hd__a211oi_1
X_06922_ _02217_ _02200_ VSS VSS VDD VDD _03524_ sky130_fd_sc_hd__nand2_1
X_06923_ _02201_ _02217_ _02182_ VSS VSS VDD VDD _03525_ sky130_fd_sc_hd__nand3_1
X_06924_ _03524_ _03525_ VSS VSS VDD VDD _03526_ sky130_fd_sc_hd__nand2_1
X_06925_ _02216_ _03523_ _03526_ VSS VSS VDD VDD _03527_ sky130_fd_sc_hd__or3_1
X_06926_ _02238_ _03527_ _02237_ VSS VSS VDD VDD _03528_ sky130_fd_sc_hd__a21oi_1
X_06927_ _02262_ _03528_ VSS VSS VDD VDD _02263_ sky130_fd_sc_hd__xor2_1
X_06928_ _03501_ _02242_ VSS VSS VDD VDD _03529_ sky130_fd_sc_hd__nor2b_1
X_06929_ _02221_ _02242_ _02266_ VSS VSS VDD VDD _03530_ sky130_fd_sc_hd__nand3_1
X_06930_ _03488_ _03493_ _03530_ _03495_ VSS VSS VDD VDD _03531_
+ sky130_fd_sc_hd__a211oi_1
X_06931_ _02242_ _02220_ _02241_ VSS VSS VDD VDD _03532_ sky130_fd_sc_hd__a21oi_1
X_06932_ _03532_ _02266_ VSS VSS VDD VDD _03533_ sky130_fd_sc_hd__nor2b_1
X_06933_ _03531_ _03533_ VSS VSS VDD VDD _03534_ sky130_fd_sc_hd__nor2_1
X_06934_ _02266_ _02241_ _03529_ _03534_ VSS VSS VDD VDD _02267_
+ sky130_fd_sc_hd__o31a_1
X_06935_ _02267_ VSS VSS VDD VDD _02270_ sky130_fd_sc_hd__inv_1
X_06936_ net447 _02233_ VSS VSS VDD VDD _00954_ sky130_fd_sc_hd__nand2_1
X_06937_ _02265_ _03531_ _03533_ VSS VSS VDD VDD _03535_ sky130_fd_sc_hd__or3_1
X_06938_ _02288_ _03535_ VSS VSS VDD VDD _02289_ sky130_fd_sc_hd__xor2_1
X_06939_ _02289_ VSS VSS VDD VDD _02292_ sky130_fd_sc_hd__inv_1
X_06940_ _00975_ VSS VSS VDD VDD _00971_ sky130_fd_sc_hd__inv_1
X_06941_ _02288_ _03535_ _02287_ VSS VSS VDD VDD _03536_ sky130_fd_sc_hd__a21oi_1
X_06942_ _02308_ _03536_ VSS VSS VDD VDD _02309_ sky130_fd_sc_hd__xnor2_1
X_06943_ _02309_ VSS VSS VDD VDD _02312_ sky130_fd_sc_hd__inv_1
X_06944_ _02308_ VSS VSS VDD VDD _03537_ sky130_fd_sc_hd__inv_1
X_06945_ _03537_ _03536_ _02307_ VSS VSS VDD VDD _03538_ sky130_fd_sc_hd__o21bai_1
X_06946_ _02331_ _03538_ VSS VSS VDD VDD _02435_ sky130_fd_sc_hd__xor2_1
X_06947_ _02435_ VSS VSS VDD VDD _02438_ sky130_fd_sc_hd__inv_1
X_06948_ _02253_ _03518_ _02252_ VSS VSS VDD VDD _03539_ sky130_fd_sc_hd__a21oi_1
X_06949_ _02275_ _02297_ _02319_ VSS VSS VDD VDD _03540_ sky130_fd_sc_hd__nand3_1
X_06950_ _02297_ _02274_ _02296_ VSS VSS VDD VDD _03541_ sky130_fd_sc_hd__a21o_1
X_06951_ _02319_ _03541_ _02318_ VSS VSS VDD VDD _03542_ sky130_fd_sc_hd__a21oi_1
X_06952_ _03539_ _03540_ _03542_ VSS VSS VDD VDD _03543_ sky130_fd_sc_hd__o21ai_0
X_06953_ _02336_ _03543_ VSS VSS VDD VDD _02347_ sky130_fd_sc_hd__xor2_1
X_06954_ _02216_ _02237_ _02261_ VSS VSS VDD VDD _03544_ sky130_fd_sc_hd__or3_1
X_06955_ _02238_ _02237_ _02261_ VSS VSS VDD VDD _03545_ sky130_fd_sc_hd__nor3_1
X_06956_ _02262_ _02261_ VSS VSS VDD VDD _03546_ sky130_fd_sc_hd__nor2_1
X_06957_ _03545_ _03546_ VSS VSS VDD VDD _03547_ sky130_fd_sc_hd__nor2_1
X_06958_ _03523_ _03526_ _03544_ _03547_ VSS VSS VDD VDD _03548_
+ sky130_fd_sc_hd__o31ai_1
X_06959_ _02284_ _02304_ _02327_ VSS VSS VDD VDD _03549_ sky130_fd_sc_hd__nand3_1
X_06960_ _02304_ _02283_ _02303_ VSS VSS VDD VDD _03550_ sky130_fd_sc_hd__a21o_1
X_06961_ _02327_ _03550_ _02326_ VSS VSS VDD VDD _03551_ sky130_fd_sc_hd__a21oi_1
X_06962_ _03548_ _03549_ _03551_ VSS VSS VDD VDD _03552_ sky130_fd_sc_hd__o21ai_0
X_06963_ _02345_ _03552_ VSS VSS VDD VDD _02346_ sky130_fd_sc_hd__xnor2_1
X_06964_ _02331_ _03538_ _02330_ VSS VSS VDD VDD _03553_ sky130_fd_sc_hd__a21oi_1
X_06965_ _02349_ _03553_ VSS VSS VDD VDD _02443_ sky130_fd_sc_hd__xor2_1
X_06966_ _02288_ _02308_ _02331_ _02349_ VSS VSS VDD VDD _03554_
+ sky130_fd_sc_hd__and4_1
X_06967_ _03531_ _03533_ _03554_ VSS VSS VDD VDD _03555_ sky130_fd_sc_hd__o21ai_0
X_06968_ _02308_ _02331_ _02349_ _02287_ VSS VSS VDD VDD _03556_
+ sky130_fd_sc_hd__and4_1
X_06969_ _02265_ _03554_ _03556_ VSS VSS VDD VDD _03557_ sky130_fd_sc_hd__a21oi_1
X_06970_ _02331_ _02307_ _02330_ VSS VSS VDD VDD _03558_ sky130_fd_sc_hd__a21o_1
X_06971_ _02349_ _03558_ _02348_ VSS VSS VDD VDD _03559_ sky130_fd_sc_hd__a21oi_1
X_06972_ _03555_ _03557_ _03559_ VSS VSS VDD VDD _03560_ sky130_fd_sc_hd__nand3_1
X_06973_ _02365_ _03560_ VSS VSS VDD VDD _02445_ sky130_fd_sc_hd__xor2_1
X_06974_ _02445_ VSS VSS VDD VDD _02448_ sky130_fd_sc_hd__inv_1
X_06975_ _02369_ VSS VSS VDD VDD _00579_ sky130_fd_sc_hd__inv_1
X_06976_ _02365_ _03560_ _02364_ VSS VSS VDD VDD _03561_ sky130_fd_sc_hd__a21oi_1
X_06977_ _02381_ _03561_ VSS VSS VDD VDD _02450_ sky130_fd_sc_hd__xnor2_1
X_06978_ _02450_ VSS VSS VDD VDD _02453_ sky130_fd_sc_hd__inv_1
X_06979_ _00590_ VSS VSS VDD VDD _01915_ sky130_fd_sc_hd__inv_1
X_06980_ _02364_ _02380_ _03559_ VSS VSS VDD VDD _03562_ sky130_fd_sc_hd__nor3b_1
X_06981_ _03555_ _03557_ _03562_ VSS VSS VDD VDD _03563_ sky130_fd_sc_hd__nand3_1
X_06982_ _02365_ _02364_ _02380_ VSS VSS VDD VDD _03564_ sky130_fd_sc_hd__nor3_1
X_06983_ _02381_ _02380_ VSS VSS VDD VDD _03565_ sky130_fd_sc_hd__nor2_1
X_06984_ _03564_ _03565_ VSS VSS VDD VDD _03566_ sky130_fd_sc_hd__nor2_1
X_06985_ _03563_ _03566_ VSS VSS VDD VDD _03567_ sky130_fd_sc_hd__and2_1
X_06986_ _02397_ _03567_ VSS VSS VDD VDD _02455_ sky130_fd_sc_hd__xor2_1
X_06987_ _02455_ VSS VSS VDD VDD _02458_ sky130_fd_sc_hd__inv_1
X_06988_ _02397_ _03563_ _03566_ _02396_ VSS VSS VDD VDD _03568_
+ sky130_fd_sc_hd__a31oi_1
X_06989_ _02413_ _03568_ VSS VSS VDD VDD _02460_ sky130_fd_sc_hd__xnor2_1
X_06990_ _02460_ VSS VSS VDD VDD _02463_ sky130_fd_sc_hd__inv_1
X_06991_ _02413_ VSS VSS VDD VDD _03569_ sky130_fd_sc_hd__inv_1
X_06992_ _03569_ _03568_ _02412_ VSS VSS VDD VDD _03570_ sky130_fd_sc_hd__o21bai_1
X_06993_ _02073_ _02082_ VSS VSS VDD VDD _03571_ sky130_fd_sc_hd__nor2_1
X_06994_ _02074_ _02073_ _02083_ VSS VSS VDD VDD _03572_ sky130_fd_sc_hd__o21a_1
X_06995_ _02082_ _03572_ VSS VSS VDD VDD _03573_ sky130_fd_sc_hd__nor2_1
X_06996_ _03461_ _03571_ _03573_ VSS VSS VDD VDD _03574_ sky130_fd_sc_hd__a21oi_1
X_06997_ _02067_ _02183_ _02201_ VSS VSS VDD VDD _03575_ sky130_fd_sc_hd__and3_1
X_06998_ _02201_ _02182_ VSS VSS VDD VDD _03576_ sky130_fd_sc_hd__nand2_1
X_06999_ _02183_ _02201_ _02066_ VSS VSS VDD VDD _03577_ sky130_fd_sc_hd__nand3_1
X_07000_ _03576_ _03577_ VSS VSS VDD VDD _03578_ sky130_fd_sc_hd__nand2_1
X_07001_ _02200_ _02216_ _02237_ VSS VSS VDD VDD _03579_ sky130_fd_sc_hd__or3_1
X_07002_ _03574_ _03575_ _03578_ _03579_ VSS VSS VDD VDD _03580_
+ sky130_fd_sc_hd__a211oi_1
X_07003_ _02217_ _02216_ _02238_ VSS VSS VDD VDD _03581_ sky130_fd_sc_hd__o21ai_0
X_07004_ _02237_ _03581_ VSS VSS VDD VDD _03582_ sky130_fd_sc_hd__nand2b_1
X_07005_ _03582_ VSS VSS VDD VDD _03583_ sky130_fd_sc_hd__inv_1
X_07006_ _02284_ _02304_ _02327_ VSS VSS VDD VDD _03584_ sky130_fd_sc_hd__and3_1
X_07007_ _02262_ _02345_ _03584_ VSS VSS VDD VDD _03585_ sky130_fd_sc_hd__nand3_1
X_07008_ _03551_ _02345_ VSS VSS VDD VDD _03586_ sky130_fd_sc_hd__nor2b_1
X_07009_ _02345_ _02261_ _03584_ _03586_ VSS VSS VDD VDD _03587_
+ sky130_fd_sc_hd__a31oi_1
X_07010_ _03580_ _03583_ _03585_ _03587_ VSS VSS VDD VDD _03588_
+ sky130_fd_sc_hd__o31ai_1
X_07011_ _02361_ _02360_ _02376_ VSS VSS VDD VDD _03589_ sky130_fd_sc_hd__nor3_1
X_07012_ _02377_ _02376_ VSS VSS VDD VDD _03590_ sky130_fd_sc_hd__nor2_1
X_07013_ _03589_ _03590_ VSS VSS VDD VDD _03591_ sky130_fd_sc_hd__nor2_1
X_07014_ _02344_ _02360_ _02376_ _03588_ _03591_ VSS VSS VDD
+ VDD _03592_ sky130_fd_sc_hd__o41ai_1
X_07015_ _02393_ _02409_ VSS VSS VDD VDD _03593_ sky130_fd_sc_hd__nand2_1
X_07016_ _02409_ _02392_ _02408_ VSS VSS VDD VDD _03594_ sky130_fd_sc_hd__a21oi_1
X_07017_ _03592_ _03593_ _03594_ VSS VSS VDD VDD _03595_ sky130_fd_sc_hd__o21ai_0
X_07018_ _02384_ _02383_ VSS VSS VDD VDD _03596_ sky130_fd_sc_hd__nor2_1
X_07019_ _03596_ _02400_ VSS VSS VDD VDD _03597_ sky130_fd_sc_hd__nor2b_1
X_07020_ _02366_ _02383_ _02399_ VSS VSS VDD VDD _03598_ sky130_fd_sc_hd__or3_1
X_07021_ _00818_ _02047_ VSS VSS VDD VDD _03599_ sky130_fd_sc_hd__nor2b_1
X_07022_ _02046_ _03599_ _02044_ VSS VSS VDD VDD _03600_ sky130_fd_sc_hd__o21ai_0
X_07023_ _03508_ _03600_ _02041_ VSS VSS VDD VDD _03601_ sky130_fd_sc_hd__a21boi_0
X_07024_ _02040_ _03601_ _02037_ VSS VSS VDD VDD _03602_ sky130_fd_sc_hd__o21ai_0
X_07025_ _03511_ _03602_ _02032_ VSS VSS VDD VDD _03603_ sky130_fd_sc_hd__a21boi_0
X_07026_ _02031_ _03603_ _02176_ VSS VSS VDD VDD _03604_ sky130_fd_sc_hd__o21ai_0
X_07027_ _03514_ _03604_ _02192_ VSS VSS VDD VDD _03605_ sky130_fd_sc_hd__a21boi_0
X_07028_ _02191_ _02209_ _03605_ VSS VSS VDD VDD _03606_ sky130_fd_sc_hd__nor3_1
X_07029_ _02210_ _02209_ _02226_ VSS VSS VDD VDD _03607_ sky130_fd_sc_hd__o21ai_0
X_07030_ _02225_ _02252_ VSS VSS VDD VDD _03608_ sky130_fd_sc_hd__nor2_1
X_07031_ _03606_ _03607_ _03608_ _03542_ VSS VSS VDD VDD _03609_
+ sky130_fd_sc_hd__o211ai_1
X_07032_ _02253_ _02252_ VSS VSS VDD VDD _03610_ sky130_fd_sc_hd__nor2_1
X_07033_ _03540_ _03610_ _03542_ VSS VSS VDD VDD _03611_ sky130_fd_sc_hd__o21ai_0
X_07034_ _03609_ _03611_ VSS VSS VDD VDD _03612_ sky130_fd_sc_hd__nand2_1
X_07035_ _02336_ _02351_ _02367_ VSS VSS VDD VDD _03613_ sky130_fd_sc_hd__nand3_1
X_07036_ _02351_ _02367_ _02335_ VSS VSS VDD VDD _03614_ sky130_fd_sc_hd__and3_1
X_07037_ _02367_ _02350_ _03614_ VSS VSS VDD VDD _03615_ sky130_fd_sc_hd__a21oi_1
X_07038_ _03612_ _03613_ _03615_ VSS VSS VDD VDD _03616_ sky130_fd_sc_hd__o21ai_0
X_07039_ _02399_ _03597_ _03598_ _03616_ VSS VSS VDD VDD _03617_
+ sky130_fd_sc_hd__o22ai_1
X_07040_ stage3_in_r\[77\] VSS VSS VDD VDD _00859_ sky130_fd_sc_hd__inv_1
X_07041_ net427 _00859_ VSS VSS VDD VDD _03618_ sky130_fd_sc_hd__nor2_1
X_07042_ _02368_ _00859_ _03618_ _02385_ VSS VSS VDD VDD _03619_
+ sky130_fd_sc_hd__a211oi_1
X_07043_ _02404_ _01044_ VSS VSS VDD VDD _03620_ sky130_fd_sc_hd__xnor2_1
X_07044_ net432 _02403_ VSS VSS VDD VDD _03621_ sky130_fd_sc_hd__xnor2_1
X_07045_ _03620_ _03621_ VSS VSS VDD VDD _03622_ sky130_fd_sc_hd__xnor2_1
X_07046_ _03619_ _03622_ VSS VSS VDD VDD _03623_ sky130_fd_sc_hd__xnor2_1
X_07047_ _03617_ _03623_ VSS VSS VDD VDD _03624_ sky130_fd_sc_hd__xnor2_1
X_07048_ _03595_ _03624_ VSS VSS VDD VDD _03625_ sky130_fd_sc_hd__xnor2_1
X_07049_ _03570_ _03625_ VSS VSS VDD VDD _02466_ sky130_fd_sc_hd__xor2_1
X_07050_ stage3_in_r\[240\] stage3_in_r\[112\] VSS VSS VDD
+ VDD _01086_ sky130_fd_sc_hd__nor2b_1
X_07051_ stage2_in_r\[16\] VSS VSS VDD VDD _02527_ sky130_fd_sc_hd__inv_1
X_07052_ stage2_in_r\[112\] stage2_in_r\[48\] VSS VSS VDD
+ VDD _01078_ sky130_fd_sc_hd__nor2b_1
X_07053_ stage2_in_r\[144\] VSS VSS VDD VDD _02589_ sky130_fd_sc_hd__inv_1
X_07054_ stage1_in_r\[48\] stage1_in_r\[16\] VSS VSS VDD VDD
+ _01065_ sky130_fd_sc_hd__nor2b_1
X_07055_ stage1_in_r\[176\] stage1_in_r\[144\] VSS VSS VDD
+ VDD _01052_ sky130_fd_sc_hd__nor2b_1
X_07056_ _01143_ VSS VSS VDD VDD _00061_ sky130_fd_sc_hd__inv_1
X_07057_ _01152_ VSS VSS VDD VDD _00072_ sky130_fd_sc_hd__inv_1
X_07058_ _01155_ VSS VSS VDD VDD _00086_ sky130_fd_sc_hd__inv_1
X_07059_ _01161_ VSS VSS VDD VDD _00094_ sky130_fd_sc_hd__inv_1
X_07060_ _01166_ VSS VSS VDD VDD _00105_ sky130_fd_sc_hd__inv_1
X_07061_ _01177_ VSS VSS VDD VDD _00117_ sky130_fd_sc_hd__inv_1
X_07062_ _01185_ VSS VSS VDD VDD _00124_ sky130_fd_sc_hd__inv_1
X_07063_ _01191_ VSS VSS VDD VDD _00129_ sky130_fd_sc_hd__inv_1
X_07064_ _01214_ VSS VSS VDD VDD _00194_ sky130_fd_sc_hd__inv_1
X_07065_ _01223_ VSS VSS VDD VDD _00205_ sky130_fd_sc_hd__inv_1
X_07066_ _01229_ VSS VSS VDD VDD _00225_ sky130_fd_sc_hd__inv_1
X_07067_ _01234_ VSS VSS VDD VDD _00235_ sky130_fd_sc_hd__inv_1
X_07068_ _01246_ VSS VSS VDD VDD _00247_ sky130_fd_sc_hd__inv_1
X_07069_ _01255_ VSS VSS VDD VDD _00253_ sky130_fd_sc_hd__inv_1
X_07070_ _01261_ VSS VSS VDD VDD _00258_ sky130_fd_sc_hd__inv_1
X_07071_ _01280_ VSS VSS VDD VDD _00263_ sky130_fd_sc_hd__inv_1
X_07072_ _01281_ VSS VSS VDD VDD _00268_ sky130_fd_sc_hd__inv_1
X_07073_ _01819_ VSS VSS VDD VDD _00512_ sky130_fd_sc_hd__inv_1
X_07074_ _01830_ VSS VSS VDD VDD _00526_ sky130_fd_sc_hd__inv_1
X_07075_ _01834_ VSS VSS VDD VDD _00530_ sky130_fd_sc_hd__inv_1
X_07076_ _01861_ VSS VSS VDD VDD _00534_ sky130_fd_sc_hd__inv_1
X_07077_ _01916_ VSS VSS VDD VDD _00589_ sky130_fd_sc_hd__inv_1
X_07078_ _02034_ VSS VSS VDD VDD _00671_ sky130_fd_sc_hd__inv_1
X_07079_ _02038_ VSS VSS VDD VDD _00675_ sky130_fd_sc_hd__inv_1
X_07080_ _02055_ VSS VSS VDD VDD _00691_ sky130_fd_sc_hd__inv_1
X_07081_ _02063_ VSS VSS VDD VDD _00738_ sky130_fd_sc_hd__inv_1
X_07082_ _02070_ VSS VSS VDD VDD _00751_ sky130_fd_sc_hd__inv_1
X_07083_ _02075_ VSS VSS VDD VDD _00779_ sky130_fd_sc_hd__inv_1
X_07084_ _02089_ VSS VSS VDD VDD _00794_ sky130_fd_sc_hd__inv_1
X_07085_ _02097_ VSS VSS VDD VDD _00805_ sky130_fd_sc_hd__inv_1
X_07086_ _02104_ VSS VSS VDD VDD _00810_ sky130_fd_sc_hd__inv_1
X_07087_ _02138_ VSS VSS VDD VDD _00815_ sky130_fd_sc_hd__inv_1
X_07088_ _02155_ VSS VSS VDD VDD _00820_ sky130_fd_sc_hd__inv_1
X_07089_ _02250_ VSS VSS VDD VDD _00933_ sky130_fd_sc_hd__inv_1
X_07090_ _00936_ VSS VSS VDD VDD _00937_ sky130_fd_sc_hd__inv_1
X_07091_ net434 VSS VSS VDD VDD _00308_ sky130_fd_sc_hd__inv_1
X_07092_ _02372_ VSS VSS VDD VDD _01038_ sky130_fd_sc_hd__inv_1
X_07093_ stage1_in_r\[209\] VSS VSS VDD VDD _01046_ sky130_fd_sc_hd__inv_1
X_07094_ stage3_in_r\[193\] VSS VSS VDD VDD _01093_ sky130_fd_sc_hd__inv_1
X_07095_ stage3_in_r\[129\] VSS VSS VDD VDD _01111_ sky130_fd_sc_hd__inv_1
X_07096_ stage3_in_r\[145\] VSS VSS VDD VDD _01098_ sky130_fd_sc_hd__inv_1
X_07097_ _01132_ VSS VSS VDD VDD _00015_ sky130_fd_sc_hd__inv_1
X_07098_ _01137_ VSS VSS VDD VDD _00035_ sky130_fd_sc_hd__inv_1
X_07099_ _01178_ VSS VSS VDD VDD _00118_ sky130_fd_sc_hd__inv_1
X_07100_ _01186_ VSS VSS VDD VDD _00125_ sky130_fd_sc_hd__inv_1
X_07101_ _01192_ VSS VSS VDD VDD _00130_ sky130_fd_sc_hd__inv_1
X_07102_ _01209_ VSS VSS VDD VDD _00171_ sky130_fd_sc_hd__inv_1
X_07103_ _01247_ VSS VSS VDD VDD _00248_ sky130_fd_sc_hd__inv_1
X_07104_ _01256_ VSS VSS VDD VDD _00254_ sky130_fd_sc_hd__inv_1
X_07105_ _01262_ VSS VSS VDD VDD _00259_ sky130_fd_sc_hd__inv_1
X_07106_ _01201_ VSS VSS VDD VDD _00264_ sky130_fd_sc_hd__inv_1
X_07107_ _01271_ VSS VSS VDD VDD _00269_ sky130_fd_sc_hd__inv_1
X_07108_ _01381_ VSS VSS VDD VDD _00393_ sky130_fd_sc_hd__inv_1
X_07109_ _01404_ VSS VSS VDD VDD _00414_ sky130_fd_sc_hd__inv_1
X_07110_ _01390_ VSS VSS VDD VDD _00426_ sky130_fd_sc_hd__inv_1
X_07111_ _01407_ VSS VSS VDD VDD _00439_ sky130_fd_sc_hd__inv_1
X_07112_ _01412_ VSS VSS VDD VDD _00443_ sky130_fd_sc_hd__inv_1
X_07113_ _01427_ VSS VSS VDD VDD _00458_ sky130_fd_sc_hd__inv_1
X_07114_ _01434_ VSS VSS VDD VDD _00464_ sky130_fd_sc_hd__inv_1
X_07115_ _01442_ VSS VSS VDD VDD _00471_ sky130_fd_sc_hd__inv_1
X_07116_ _01450_ VSS VSS VDD VDD _00477_ sky130_fd_sc_hd__inv_1
X_07117_ _01459_ VSS VSS VDD VDD _00481_ sky130_fd_sc_hd__inv_1
X_07118_ _01468_ VSS VSS VDD VDD _00487_ sky130_fd_sc_hd__inv_1
X_07119_ _01476_ VSS VSS VDD VDD _00491_ sky130_fd_sc_hd__inv_1
X_07120_ _01486_ VSS VSS VDD VDD _00495_ sky130_fd_sc_hd__inv_1
X_07121_ _01497_ VSS VSS VDD VDD _00499_ sky130_fd_sc_hd__inv_1
X_07122_ _01507_ VSS VSS VDD VDD _00503_ sky130_fd_sc_hd__inv_1
X_07123_ _01816_ VSS VSS VDD VDD _00510_ sky130_fd_sc_hd__inv_1
X_07124_ _01820_ VSS VSS VDD VDD _00517_ sky130_fd_sc_hd__inv_1
X_07125_ _01831_ VSS VSS VDD VDD _00527_ sky130_fd_sc_hd__inv_1
X_07126_ _01835_ VSS VSS VDD VDD _00531_ sky130_fd_sc_hd__inv_1
X_07127_ _01848_ VSS VSS VDD VDD _00535_ sky130_fd_sc_hd__inv_1
X_07128_ _01814_ VSS VSS VDD VDD _00542_ sky130_fd_sc_hd__inv_1
X_07129_ _01953_ VSS VSS VDD VDD _00647_ sky130_fd_sc_hd__inv_1
X_07130_ _02022_ VSS VSS VDD VDD _00653_ sky130_fd_sc_hd__inv_1
X_07131_ _02024_ VSS VSS VDD VDD _00660_ sky130_fd_sc_hd__inv_1
X_07132_ _02027_ VSS VSS VDD VDD _00666_ sky130_fd_sc_hd__inv_1
X_07133_ _02035_ VSS VSS VDD VDD _00672_ sky130_fd_sc_hd__inv_1
X_07134_ _02039_ VSS VSS VDD VDD _00676_ sky130_fd_sc_hd__inv_1
X_07135_ _02059_ VSS VSS VDD VDD _00712_ sky130_fd_sc_hd__inv_1
X_07136_ _01828_ VSS VSS VDD VDD _00759_ sky130_fd_sc_hd__inv_1
X_07137_ _02090_ VSS VSS VDD VDD _00795_ sky130_fd_sc_hd__inv_1
X_07138_ _02099_ VSS VSS VDD VDD _00806_ sky130_fd_sc_hd__inv_1
X_07139_ _02106_ VSS VSS VDD VDD _00811_ sky130_fd_sc_hd__inv_1
X_07140_ _02049_ VSS VSS VDD VDD _00816_ sky130_fd_sc_hd__inv_1
X_07141_ _02115_ VSS VSS VDD VDD _00821_ sky130_fd_sc_hd__inv_1
X_07142_ _02020_ VSS VSS VDD VDD _00826_ sky130_fd_sc_hd__inv_1
X_07143_ _00898_ VSS VSS VDD VDD _00920_ sky130_fd_sc_hd__inv_1
X_07144_ _00918_ VSS VSS VDD VDD _00945_ sky130_fd_sc_hd__inv_1
X_07145_ _02300_ VSS VSS VDD VDD _00990_ sky130_fd_sc_hd__inv_1
X_07146_ _02322_ VSS VSS VDD VDD _01006_ sky130_fd_sc_hd__inv_1
X_07147_ _02340_ VSS VSS VDD VDD _01022_ sky130_fd_sc_hd__inv_1
X_07148_ _02356_ VSS VSS VDD VDD _01030_ sky130_fd_sc_hd__inv_1
X_07149_ _01494_ VSS VSS VDD VDD _01034_ sky130_fd_sc_hd__inv_1
X_07150_ stage1_in_r\[241\] VSS VSS VDD VDD _01047_ sky130_fd_sc_hd__inv_1
X_07151_ stage1_in_r\[177\] VSS VSS VDD VDD _01051_ sky130_fd_sc_hd__inv_1
X_07152_ stage1_in_r\[113\] VSS VSS VDD VDD _01060_ sky130_fd_sc_hd__inv_1
X_07153_ stage1_in_r\[49\] VSS VSS VDD VDD _01064_ sky130_fd_sc_hd__inv_1
X_07154_ stage2_in_r\[241\] VSS VSS VDD VDD _01073_ sky130_fd_sc_hd__inv_1
X_07155_ stage2_in_r\[113\] VSS VSS VDD VDD _01077_ sky130_fd_sc_hd__inv_1
X_07156_ stage3_in_r\[241\] VSS VSS VDD VDD _01085_ sky130_fd_sc_hd__inv_1
X_07157_ stage3_in_r\[192\] _03311_ _03312_ VSS VSS VDD VDD
+ _01103_ sky130_fd_sc_hd__nand3_1
X_07158_ _02125_ _03481_ VSS VSS VDD VDD _03626_ sky130_fd_sc_hd__xor2_1
X_07159_ net458 _03626_ VSS VSS VDD VDD _01107_ sky130_fd_sc_hd__nand2_1
X_07160_ _00011_ VSS VSS VDD VDD _00018_ sky130_fd_sc_hd__inv_1
X_07161_ _00053_ VSS VSS VDD VDD _00063_ sky130_fd_sc_hd__inv_1
X_07162_ _00067_ VSS VSS VDD VDD _00074_ sky130_fd_sc_hd__inv_1
X_07163_ _00002_ VSS VSS VDD VDD _00005_ sky130_fd_sc_hd__inv_1
X_07164_ _00085_ VSS VSS VDD VDD _00096_ sky130_fd_sc_hd__inv_1
X_07165_ _00101_ VSS VSS VDD VDD _00107_ sky130_fd_sc_hd__inv_1
X_07166_ _00187_ VSS VSS VDD VDD _00196_ sky130_fd_sc_hd__inv_1
X_07167_ _00200_ VSS VSS VDD VDD _00207_ sky130_fd_sc_hd__inv_1
X_07168_ _00217_ VSS VSS VDD VDD _00227_ sky130_fd_sc_hd__inv_1
X_07169_ _00231_ VSS VSS VDD VDD _00237_ sky130_fd_sc_hd__inv_1
X_07170_ _00373_ VSS VSS VDD VDD _00375_ sky130_fd_sc_hd__inv_1
X_07171_ _00404_ VSS VSS VDD VDD _00406_ sky130_fd_sc_hd__inv_1
X_07172_ _01815_ VSS VSS VDD VDD _00511_ sky130_fd_sc_hd__inv_1
X_07173_ _01883_ VSS VSS VDD VDD _00543_ sky130_fd_sc_hd__inv_1
X_07174_ _00686_ VSS VSS VDD VDD _00591_ sky130_fd_sc_hd__inv_1
X_07175_ _01944_ VSS VSS VDD VDD _00634_ sky130_fd_sc_hd__inv_1
X_07176_ _02021_ VSS VSS VDD VDD _00654_ sky130_fd_sc_hd__inv_1
X_07177_ _01129_ VSS VSS VDD VDD _00656_ sky130_fd_sc_hd__inv_1
X_07178_ _00123_ VSS VSS VDD VDD _00667_ sky130_fd_sc_hd__inv_1
X_07179_ _00689_ VSS VSS VDD VDD _00695_ sky130_fd_sc_hd__inv_1
X_07180_ _00729_ VSS VSS VDD VDD _00740_ sky130_fd_sc_hd__inv_1
X_07181_ stage3_in_r\[71\] VSS VSS VDD VDD _00719_ sky130_fd_sc_hd__inv_1
X_07182_ _00744_ VSS VSS VDD VDD _00753_ sky130_fd_sc_hd__inv_1
X_07183_ stage3_in_r\[70\] VSS VSS VDD VDD _00711_ sky130_fd_sc_hd__inv_1
X_07184_ _00770_ VSS VSS VDD VDD _00781_ sky130_fd_sc_hd__inv_1
X_07185_ _02172_ VSS VSS VDD VDD _00827_ sky130_fd_sc_hd__inv_1
X_07186_ _00919_ VSS VSS VDD VDD _00921_ sky130_fd_sc_hd__inv_1
X_07187_ _00923_ VSS VSS VDD VDD _00925_ sky130_fd_sc_hd__inv_1
X_07188_ _00007_ VSS VSS VDD VDD _00009_ sky130_fd_sc_hd__inv_1
X_07189_ _00944_ VSS VSS VDD VDD _00946_ sky130_fd_sc_hd__inv_1
X_07190_ _02254_ VSS VSS VDD VDD _00947_ sky130_fd_sc_hd__inv_1
X_07191_ _02276_ VSS VSS VDD VDD _00966_ sky130_fd_sc_hd__inv_1
X_07192_ _02332_ VSS VSS VDD VDD _01011_ sky130_fd_sc_hd__inv_1
X_07193_ _02388_ VSS VSS VDD VDD _01043_ sky130_fd_sc_hd__inv_1
X_07194_ stage1_in_r\[208\] stage1_in_r\[240\] VSS VSS VDD
+ VDD _01048_ sky130_fd_sc_hd__nand2_1
X_07195_ stage1_in_r\[144\] stage1_in_r\[176\] VSS VSS VDD
+ VDD _01056_ sky130_fd_sc_hd__nand2_1
X_07196_ stage1_in_r\[80\] stage1_in_r\[112\] VSS VSS VDD
+ VDD _01061_ sky130_fd_sc_hd__nand2_1
X_07197_ stage1_in_r\[16\] stage1_in_r\[48\] VSS VSS VDD VDD
+ _01069_ sky130_fd_sc_hd__nand2_1
X_07198_ stage2_in_r\[176\] stage2_in_r\[240\] VSS VSS VDD
+ VDD _01074_ sky130_fd_sc_hd__nand2_1
X_07199_ stage2_in_r\[48\] stage2_in_r\[112\] VSS VSS VDD
+ VDD _01082_ sky130_fd_sc_hd__nand2_1
X_07200_ stage3_in_r\[112\] stage3_in_r\[240\] VSS VSS VDD
+ VDD _01090_ sky130_fd_sc_hd__nand2_1
X_07201_ _00017_ VSS VSS VDD VDD _00032_ sky130_fd_sc_hd__inv_1
X_07202_ _00028_ VSS VSS VDD VDD _00040_ sky130_fd_sc_hd__inv_1
X_07203_ _00043_ VSS VSS VDD VDD _00056_ sky130_fd_sc_hd__inv_1
X_07204_ _00047_ VSS VSS VDD VDD _00051_ sky130_fd_sc_hd__inv_1
X_07205_ _00058_ VSS VSS VDD VDD _00103_ sky130_fd_sc_hd__inv_1
X_07206_ _00083_ VSS VSS VDD VDD _00090_ sky130_fd_sc_hd__inv_1
X_07207_ _00093_ VSS VSS VDD VDD _00102_ sky130_fd_sc_hd__inv_1
X_07208_ _00114_ VSS VSS VDD VDD _01176_ sky130_fd_sc_hd__inv_1
X_07209_ _00165_ VSS VSS VDD VDD _00176_ sky130_fd_sc_hd__inv_1
X_07210_ _00179_ VSS VSS VDD VDD _00190_ sky130_fd_sc_hd__inv_1
X_07211_ _00192_ VSS VSS VDD VDD _00233_ sky130_fd_sc_hd__inv_1
X_07212_ _00216_ VSS VSS VDD VDD _00221_ sky130_fd_sc_hd__inv_1
X_07213_ _00224_ VSS VSS VDD VDD _00232_ sky130_fd_sc_hd__inv_1
X_07214_ _00244_ VSS VSS VDD VDD _01245_ sky130_fd_sc_hd__inv_1
X_07215_ _00297_ VSS VSS VDD VDD _00298_ sky130_fd_sc_hd__inv_1
X_07216_ _00398_ VSS VSS VDD VDD _01384_ sky130_fd_sc_hd__inv_1
X_07217_ _00694_ VSS VSS VDD VDD _00709_ sky130_fd_sc_hd__inv_1
X_07218_ _00705_ VSS VSS VDD VDD _00717_ sky130_fd_sc_hd__inv_1
X_07219_ _00720_ VSS VSS VDD VDD _00732_ sky130_fd_sc_hd__inv_1
X_07220_ _00723_ VSS VSS VDD VDD _00727_ sky130_fd_sc_hd__inv_1
X_07221_ _00734_ VSS VSS VDD VDD _00747_ sky130_fd_sc_hd__inv_1
X_07222_ _00737_ VSS VSS VDD VDD _00745_ sky130_fd_sc_hd__inv_1
X_07223_ _00750_ VSS VSS VDD VDD _00764_ sky130_fd_sc_hd__inv_1
X_07224_ _00762_ VSS VSS VDD VDD _00769_ sky130_fd_sc_hd__inv_1
X_07225_ _00767_ VSS VSS VDD VDD _00775_ sky130_fd_sc_hd__inv_1
X_07226_ _00778_ VSS VSS VDD VDD _00786_ sky130_fd_sc_hd__inv_1
X_07227_ _00791_ VSS VSS VDD VDD _02088_ sky130_fd_sc_hd__inv_1
X_07228_ _00951_ VSS VSS VDD VDD _02279_ sky130_fd_sc_hd__inv_1
X_07229_ _01050_ VSS VSS VDD VDD stage1_out\[240\] sky130_fd_sc_hd__inv_1
X_07230_ _01054_ VSS VSS VDD VDD stage1_out\[144\] sky130_fd_sc_hd__inv_1
X_07231_ _01058_ VSS VSS VDD VDD stage1_out\[176\] sky130_fd_sc_hd__inv_1
X_07232_ _01063_ VSS VSS VDD VDD stage1_out\[112\] sky130_fd_sc_hd__inv_1
X_07233_ _01067_ VSS VSS VDD VDD stage1_out\[16\] sky130_fd_sc_hd__inv_1
X_07234_ _01071_ VSS VSS VDD VDD stage1_out\[48\] sky130_fd_sc_hd__inv_1
X_07235_ _01076_ VSS VSS VDD VDD stage2_out\[240\] sky130_fd_sc_hd__inv_1
X_07236_ _01080_ VSS VSS VDD VDD stage2_out\[48\] sky130_fd_sc_hd__inv_1
X_07237_ _01084_ VSS VSS VDD VDD stage2_out\[112\] sky130_fd_sc_hd__inv_1
X_07238_ _01088_ VSS VSS VDD VDD stage3_out\[112\] sky130_fd_sc_hd__inv_1
X_07239_ _01092_ VSS VSS VDD VDD stage3_out\[240\] sky130_fd_sc_hd__inv_1
X_07240_ _00004_ VSS VSS VDD VDD _00013_ sky130_fd_sc_hd__inv_1
X_07241_ _00104_ VSS VSS VDD VDD _00112_ sky130_fd_sc_hd__inv_1
X_07242_ _00136_ VSS VSS VDD VDD _00139_ sky130_fd_sc_hd__inv_1
X_07243_ _00234_ VSS VSS VDD VDD _00242_ sky130_fd_sc_hd__inv_1
X_07244_ _00275_ VSS VSS VDD VDD _00283_ sky130_fd_sc_hd__inv_1
X_07245_ _00277_ VSS VSS VDD VDD _00279_ sky130_fd_sc_hd__inv_1
X_07246_ _00291_ VSS VSS VDD VDD _00299_ sky130_fd_sc_hd__inv_1
X_07247_ _00307_ VSS VSS VDD VDD _00314_ sky130_fd_sc_hd__inv_1
X_07248_ _00321_ VSS VSS VDD VDD _00326_ sky130_fd_sc_hd__inv_1
X_07249_ _00333_ VSS VSS VDD VDD _00336_ sky130_fd_sc_hd__inv_1
X_07250_ _00343_ VSS VSS VDD VDD _00346_ sky130_fd_sc_hd__inv_1
X_07251_ _00354_ VSS VSS VDD VDD _00357_ sky130_fd_sc_hd__inv_1
X_07252_ _00364_ VSS VSS VDD VDD _00367_ sky130_fd_sc_hd__inv_1
X_07253_ _00385_ VSS VSS VDD VDD _00388_ sky130_fd_sc_hd__inv_1
X_07254_ _00508_ VSS VSS VDD VDD _00509_ sky130_fd_sc_hd__inv_1
X_07255_ _00540_ VSS VSS VDD VDD _00541_ sky130_fd_sc_hd__inv_1
X_07256_ _00551_ VSS VSS VDD VDD _00553_ sky130_fd_sc_hd__inv_1
X_07257_ _00560_ VSS VSS VDD VDD _00563_ sky130_fd_sc_hd__inv_1
X_07258_ _00571_ VSS VSS VDD VDD _00574_ sky130_fd_sc_hd__inv_1
X_07259_ _00581_ VSS VSS VDD VDD _00584_ sky130_fd_sc_hd__inv_1
X_07260_ _00596_ VSS VSS VDD VDD _00599_ sky130_fd_sc_hd__inv_1
X_07261_ _00605_ VSS VSS VDD VDD _00608_ sky130_fd_sc_hd__inv_1
X_07262_ _00615_ VSS VSS VDD VDD _00618_ sky130_fd_sc_hd__inv_1
X_07263_ _00624_ VSS VSS VDD VDD _00627_ sky130_fd_sc_hd__inv_1
X_07264_ _00651_ VSS VSS VDD VDD _00652_ sky130_fd_sc_hd__inv_1
X_07265_ _00681_ VSS VSS VDD VDD _00683_ sky130_fd_sc_hd__inv_1
X_07266_ _00787_ VSS VSS VDD VDD _00789_ sky130_fd_sc_hd__inv_1
X_07267_ _00799_ VSS VSS VDD VDD _00801_ sky130_fd_sc_hd__inv_1
X_07268_ _00824_ VSS VSS VDD VDD _00825_ sky130_fd_sc_hd__inv_1
X_07269_ _00834_ VSS VSS VDD VDD _00841_ sky130_fd_sc_hd__inv_1
X_07270_ _00836_ VSS VSS VDD VDD _00838_ sky130_fd_sc_hd__inv_1
X_07271_ _00849_ VSS VSS VDD VDD _00851_ sky130_fd_sc_hd__inv_1
X_07272_ _00858_ VSS VSS VDD VDD _00864_ sky130_fd_sc_hd__inv_1
X_07273_ _00872_ VSS VSS VDD VDD _00875_ sky130_fd_sc_hd__inv_1
X_07274_ _00883_ VSS VSS VDD VDD _00886_ sky130_fd_sc_hd__inv_1
X_07275_ _00894_ VSS VSS VDD VDD _00897_ sky130_fd_sc_hd__inv_1
X_07276_ _00904_ VSS VSS VDD VDD _00907_ sky130_fd_sc_hd__inv_1
X_07277_ _00914_ VSS VSS VDD VDD _00917_ sky130_fd_sc_hd__inv_1
X_07278_ _00939_ VSS VSS VDD VDD _00942_ sky130_fd_sc_hd__inv_1
X_07279_ _00958_ VSS VSS VDD VDD _00961_ sky130_fd_sc_hd__inv_1
X_07280_ _00979_ VSS VSS VDD VDD _00982_ sky130_fd_sc_hd__inv_1
X_07281_ _00995_ VSS VSS VDD VDD _00998_ sky130_fd_sc_hd__inv_1
X_07282_ _01097_ VSS VSS VDD VDD stage3_out\[64\] sky130_fd_sc_hd__inv_1
X_07283_ _01102_ VSS VSS VDD VDD stage3_out\[80\] sky130_fd_sc_hd__inv_1
X_07284_ _01106_ VSS VSS VDD VDD stage3_out\[192\] sky130_fd_sc_hd__inv_1
X_07285_ _01110_ VSS VSS VDD VDD stage3_out\[208\] sky130_fd_sc_hd__inv_1
X_07286_ _01115_ VSS VSS VDD VDD stage3_out\[0\] sky130_fd_sc_hd__inv_1
X_07287_ _01120_ VSS VSS VDD VDD stage3_out\[16\] sky130_fd_sc_hd__inv_1
X_07288_ _00003_ VSS VSS VDD VDD _00282_ sky130_fd_sc_hd__inv_1
X_07289_ _00008_ VSS VSS VDD VDD _00278_ sky130_fd_sc_hd__inv_1
X_07290_ _00033_ VSS VSS VDD VDD _00030_ sky130_fd_sc_hd__inv_1
X_07291_ _00052_ VSS VSS VDD VDD _00048_ sky130_fd_sc_hd__inv_1
X_07292_ _00066_ VSS VSS VDD VDD _00062_ sky130_fd_sc_hd__inv_1
X_07293_ _00077_ VSS VSS VDD VDD _00073_ sky130_fd_sc_hd__inv_1
X_07294_ _00100_ VSS VSS VDD VDD _00095_ sky130_fd_sc_hd__inv_1
X_07295_ _00110_ VSS VSS VDD VDD _00106_ sky130_fd_sc_hd__inv_1
X_07296_ _00115_ VSS VSS VDD VDD _00111_ sky130_fd_sc_hd__inv_1
X_07297_ _00140_ VSS VSS VDD VDD _00293_ sky130_fd_sc_hd__inv_1
X_07298_ _00154_ VSS VSS VDD VDD _00152_ sky130_fd_sc_hd__inv_1
X_07299_ _00169_ VSS VSS VDD VDD _00167_ sky130_fd_sc_hd__inv_1
X_07300_ _00181_ VSS VSS VDD VDD _00182_ sky130_fd_sc_hd__inv_1
X_07301_ _00186_ VSS VSS VDD VDD _00183_ sky130_fd_sc_hd__inv_1
X_07302_ _00199_ VSS VSS VDD VDD _00195_ sky130_fd_sc_hd__inv_1
X_07303_ _00210_ VSS VSS VDD VDD _00206_ sky130_fd_sc_hd__inv_1
X_07304_ _00230_ VSS VSS VDD VDD _00226_ sky130_fd_sc_hd__inv_1
X_07305_ _00240_ VSS VSS VDD VDD _00236_ sky130_fd_sc_hd__inv_1
X_07306_ _00245_ VSS VSS VDD VDD _00241_ sky130_fd_sc_hd__inv_1
X_07307_ _00274_ VSS VSS VDD VDD _00313_ sky130_fd_sc_hd__inv_1
X_07308_ _00290_ VSS VSS VDD VDD _00325_ sky130_fd_sc_hd__inv_1
X_07309_ _00306_ VSS VSS VDD VDD _00335_ sky130_fd_sc_hd__inv_1
X_07310_ _00320_ VSS VSS VDD VDD _00345_ sky130_fd_sc_hd__inv_1
X_07311_ _00332_ VSS VSS VDD VDD _00356_ sky130_fd_sc_hd__inv_1
X_07312_ _00342_ VSS VSS VDD VDD _00366_ sky130_fd_sc_hd__inv_1
X_07313_ _00352_ VSS VSS VDD VDD _00374_ sky130_fd_sc_hd__inv_1
X_07314_ _00353_ VSS VSS VDD VDD _00378_ sky130_fd_sc_hd__inv_1
X_07315_ _00363_ VSS VSS VDD VDD _00387_ sky130_fd_sc_hd__inv_1
X_07316_ _00372_ VSS VSS VDD VDD _00396_ sky130_fd_sc_hd__inv_1
X_07317_ _00383_ VSS VSS VDD VDD _00405_ sky130_fd_sc_hd__inv_1
X_07318_ _00384_ VSS VSS VDD VDD _00409_ sky130_fd_sc_hd__inv_1
X_07319_ _00550_ VSS VSS VDD VDD _00562_ sky130_fd_sc_hd__inv_1
X_07320_ _00559_ VSS VSS VDD VDD _00573_ sky130_fd_sc_hd__inv_1
X_07321_ _00570_ VSS VSS VDD VDD _00583_ sky130_fd_sc_hd__inv_1
X_07322_ _00580_ VSS VSS VDD VDD _00598_ sky130_fd_sc_hd__inv_1
X_07323_ _00595_ VSS VSS VDD VDD _00607_ sky130_fd_sc_hd__inv_1
X_07324_ _00604_ VSS VSS VDD VDD _00617_ sky130_fd_sc_hd__inv_1
X_07325_ _00614_ VSS VSS VDD VDD _00626_ sky130_fd_sc_hd__inv_1
X_07326_ _00623_ VSS VSS VDD VDD _00637_ sky130_fd_sc_hd__inv_1
X_07327_ _00644_ VSS VSS VDD VDD _00648_ sky130_fd_sc_hd__inv_1
X_07328_ _00687_ VSS VSS VDD VDD _00837_ sky130_fd_sc_hd__inv_1
X_07329_ _00710_ VSS VSS VDD VDD _00707_ sky130_fd_sc_hd__inv_1
X_07330_ _00728_ VSS VSS VDD VDD _00724_ sky130_fd_sc_hd__inv_1
X_07331_ _00743_ VSS VSS VDD VDD _00739_ sky130_fd_sc_hd__inv_1
X_07332_ _00757_ VSS VSS VDD VDD _00752_ sky130_fd_sc_hd__inv_1
X_07333_ _00785_ VSS VSS VDD VDD _00780_ sky130_fd_sc_hd__inv_1
X_07334_ _00792_ VSS VSS VDD VDD _00788_ sky130_fd_sc_hd__inv_1
X_07335_ _00803_ VSS VSS VDD VDD _02098_ sky130_fd_sc_hd__inv_1
X_07336_ _00833_ VSS VSS VDD VDD _00863_ sky130_fd_sc_hd__inv_1
X_07337_ _00848_ VSS VSS VDD VDD _00874_ sky130_fd_sc_hd__inv_1
X_07338_ _00857_ VSS VSS VDD VDD _00885_ sky130_fd_sc_hd__inv_1
X_07339_ _00871_ VSS VSS VDD VDD _00896_ sky130_fd_sc_hd__inv_1
X_07340_ _00882_ VSS VSS VDD VDD _00906_ sky130_fd_sc_hd__inv_1
X_07341_ _00893_ VSS VSS VDD VDD _00916_ sky130_fd_sc_hd__inv_1
X_07342_ _00902_ VSS VSS VDD VDD _00924_ sky130_fd_sc_hd__inv_1
X_07343_ _00903_ VSS VSS VDD VDD _00928_ sky130_fd_sc_hd__inv_1
X_07344_ _00913_ VSS VSS VDD VDD _00941_ sky130_fd_sc_hd__inv_1
X_07345_ _00922_ VSS VSS VDD VDD _00949_ sky130_fd_sc_hd__inv_1
X_07346_ _00938_ VSS VSS VDD VDD _00960_ sky130_fd_sc_hd__inv_1
X_07347_ _00957_ VSS VSS VDD VDD _00981_ sky130_fd_sc_hd__inv_1
X_07348_ _00978_ VSS VSS VDD VDD _00997_ sky130_fd_sc_hd__inv_1
X_07349_ _00994_ VSS VSS VDD VDD _01014_ sky130_fd_sc_hd__inv_1
X_07350_ _01028_ VSS VSS VDD VDD _01035_ sky130_fd_sc_hd__inv_1
X_07351_ net445 VSS VSS VDD VDD _00000_ sky130_fd_sc_hd__inv_1
X_07352_ _00021_ VSS VSS VDD VDD _01134_ sky130_fd_sc_hd__inv_1
X_07353_ _00037_ VSS VSS VDD VDD _00031_ sky130_fd_sc_hd__inv_1
X_07354_ _00069_ VSS VSS VDD VDD _01142_ sky130_fd_sc_hd__inv_1
X_07355_ _00064_ VSS VSS VDD VDD _01144_ sky130_fd_sc_hd__inv_1
X_07356_ _00080_ VSS VSS VDD VDD _01149_ sky130_fd_sc_hd__inv_1
X_07357_ _00060_ VSS VSS VDD VDD _01151_ sky130_fd_sc_hd__inv_1
X_07358_ stage3_in_r\[17\] VSS VSS VDD VDD _01153_ sky130_fd_sc_hd__inv_1
X_07359_ _00001_ VSS VSS VDD VDD _01156_ sky130_fd_sc_hd__inv_1
X_07360_ _00087_ VSS VSS VDD VDD _00084_ sky130_fd_sc_hd__inv_1
X_07361_ _00097_ VSS VSS VDD VDD _01162_ sky130_fd_sc_hd__inv_1
X_07362_ _00113_ VSS VSS VDD VDD _01165_ sky130_fd_sc_hd__inv_1
X_07363_ _00075_ VSS VSS VDD VDD _01167_ sky130_fd_sc_hd__inv_1
X_07364_ _00108_ VSS VSS VDD VDD _01171_ sky130_fd_sc_hd__inv_1
X_07365_ _00120_ VSS VSS VDD VDD _00116_ sky130_fd_sc_hd__inv_1
X_07366_ _00127_ VSS VSS VDD VDD _01187_ sky130_fd_sc_hd__inv_1
X_07367_ _00132_ VSS VSS VDD VDD _01193_ sky130_fd_sc_hd__inv_1
X_07368_ stage3_in_r\[0\] VSS VSS VDD VDD _00134_ sky130_fd_sc_hd__inv_1
X_07369_ stage3_in_r\[5\] VSS VSS VDD VDD _00204_ sky130_fd_sc_hd__inv_1
X_07370_ _00157_ VSS VSS VDD VDD _01206_ sky130_fd_sc_hd__inv_1
X_07371_ _00173_ VSS VSS VDD VDD _00168_ sky130_fd_sc_hd__inv_1
X_07372_ _00149_ VSS VSS VDD VDD _00180_ sky130_fd_sc_hd__inv_1
X_07373_ _00202_ VSS VSS VDD VDD _01213_ sky130_fd_sc_hd__inv_1
X_07374_ _00197_ VSS VSS VDD VDD _01215_ sky130_fd_sc_hd__inv_1
X_07375_ _00213_ VSS VSS VDD VDD _01220_ sky130_fd_sc_hd__inv_1
X_07376_ _00193_ VSS VSS VDD VDD _01222_ sky130_fd_sc_hd__inv_1
X_07377_ stage3_in_r\[1\] VSS VSS VDD VDD _01224_ sky130_fd_sc_hd__inv_1
X_07378_ _00135_ VSS VSS VDD VDD _00218_ sky130_fd_sc_hd__inv_1
X_07379_ _00228_ VSS VSS VDD VDD _01230_ sky130_fd_sc_hd__inv_1
X_07380_ _00243_ VSS VSS VDD VDD _01233_ sky130_fd_sc_hd__inv_1
X_07381_ _00208_ VSS VSS VDD VDD _01235_ sky130_fd_sc_hd__inv_1
X_07382_ _00238_ VSS VSS VDD VDD _01239_ sky130_fd_sc_hd__inv_1
X_07383_ _00250_ VSS VSS VDD VDD _00246_ sky130_fd_sc_hd__inv_1
X_07384_ _00256_ VSS VSS VDD VDD _01257_ sky130_fd_sc_hd__inv_1
X_07385_ _00261_ VSS VSS VDD VDD _01263_ sky130_fd_sc_hd__inv_1
X_07386_ net444 VSS VSS VDD VDD _01284_ sky130_fd_sc_hd__inv_1
X_07387_ _00049_ VSS VSS VDD VDD _01287_ sky130_fd_sc_hd__inv_1
X_07388_ stage3_in_r\[2\] VSS VSS VDD VDD _01291_ sky130_fd_sc_hd__inv_1
X_07389_ _00295_ VSS VSS VDD VDD _00296_ sky130_fd_sc_hd__inv_1
X_07390_ _00184_ VSS VSS VDD VDD _01294_ sky130_fd_sc_hd__inv_1
X_07391_ _00286_ VSS VSS VDD VDD _01305_ sky130_fd_sc_hd__inv_1
X_07392_ stage3_in_r\[3\] VSS VSS VDD VDD _00222_ sky130_fd_sc_hd__inv_1
X_07393_ _00294_ VSS VSS VDD VDD _01310_ sky130_fd_sc_hd__inv_1
X_07394_ _00302_ VSS VSS VDD VDD _01315_ sky130_fd_sc_hd__inv_1
X_07395_ _01299_ _00010_ VSS VSS VDD VDD _03627_ sky130_fd_sc_hd__nand2_1
X_07396_ _01299_ net430 _03627_ VSS VSS VDD VDD _01319_ sky130_fd_sc_hd__o21ai_0
X_07397_ _00317_ VSS VSS VDD VDD _01322_ sky130_fd_sc_hd__inv_1
X_07398_ stage3_in_r\[4\] VSS VSS VDD VDD _00215_ sky130_fd_sc_hd__inv_1
X_07399_ _00329_ VSS VSS VDD VDD _01329_ sky130_fd_sc_hd__inv_1
X_07400_ stage3_in_r\[21\] VSS VSS VDD VDD _00071_ sky130_fd_sc_hd__inv_2
X_07401_ _00310_ VSS VSS VDD VDD _01337_ sky130_fd_sc_hd__inv_1
X_07402_ _00339_ VSS VSS VDD VDD _01341_ sky130_fd_sc_hd__inv_1
X_07403_ net429 _01205_ _03074_ VSS VSS VDD VDD _01345_ sky130_fd_sc_hd__o21ai_0
X_07404_ _00349_ VSS VSS VDD VDD _01348_ sky130_fd_sc_hd__inv_1
X_07405_ _00360_ VSS VSS VDD VDD _01361_ sky130_fd_sc_hd__inv_1
X_07406_ stage3_in_r\[6\] VSS VSS VDD VDD _00170_ sky130_fd_sc_hd__inv_2
X_07407_ _00144_ VSS VSS VDD VDD _01292_ sky130_fd_sc_hd__inv_1
X_07408_ _00370_ VSS VSS VDD VDD _01372_ sky130_fd_sc_hd__inv_1
X_07409_ _00376_ VSS VSS VDD VDD _01383_ sky130_fd_sc_hd__inv_1
X_07410_ _00381_ VSS VSS VDD VDD _01386_ sky130_fd_sc_hd__inv_1
X_07411_ stage3_in_r\[7\] VSS VSS VDD VDD _00178_ sky130_fd_sc_hd__inv_1
X_07412_ _00391_ VSS VSS VDD VDD _01395_ sky130_fd_sc_hd__inv_1
X_07413_ _00395_ VSS VSS VDD VDD _00418_ sky130_fd_sc_hd__inv_1
X_07414_ _00397_ VSS VSS VDD VDD _01406_ sky130_fd_sc_hd__inv_1
X_07415_ _00402_ VSS VSS VDD VDD _01408_ sky130_fd_sc_hd__inv_1
X_07416_ stage3_in_r\[8\] VSS VSS VDD VDD _00162_ sky130_fd_sc_hd__inv_1
X_07417_ _00407_ VSS VSS VDD VDD _01414_ sky130_fd_sc_hd__inv_1
X_07418_ _00412_ VSS VSS VDD VDD _01416_ sky130_fd_sc_hd__inv_1
X_07419_ _00422_ VSS VSS VDD VDD _01429_ sky130_fd_sc_hd__inv_1
X_07420_ stage3_in_r\[9\] VSS VSS VDD VDD _00163_ sky130_fd_sc_hd__inv_1
X_07421_ _00428_ VSS VSS VDD VDD _00447_ sky130_fd_sc_hd__inv_1
X_07422_ _00434_ VSS VSS VDD VDD _01435_ sky130_fd_sc_hd__inv_1
X_07423_ net431 _01425_ VSS VSS VDD VDD _03628_ sky130_fd_sc_hd__nor2_1
X_07424_ _00416_ _01425_ _03628_ VSS VSS VDD VDD _01440_ sky130_fd_sc_hd__a21oi_1
X_07425_ _00441_ VSS VSS VDD VDD _01444_ sky130_fd_sc_hd__inv_1
X_07426_ stage3_in_r\[10\] VSS VSS VDD VDD _00164_ sky130_fd_sc_hd__inv_1
X_07427_ _00451_ VSS VSS VDD VDD _01452_ sky130_fd_sc_hd__inv_1
X_07428_ _01439_ _00437_ VSS VSS VDD VDD _03629_ sky130_fd_sc_hd__nand2_1
X_07429_ net430 _01439_ _03629_ VSS VSS VDD VDD _01457_ sky130_fd_sc_hd__o21ai_0
X_07430_ _00460_ VSS VSS VDD VDD _01461_ sky130_fd_sc_hd__inv_1
X_07431_ stage3_in_r\[11\] VSS VSS VDD VDD _00147_ sky130_fd_sc_hd__inv_1
X_07432_ net459 _01448_ VSS VSS VDD VDD _03630_ sky130_fd_sc_hd__nor2_1
X_07433_ _00445_ _01448_ _03630_ VSS VSS VDD VDD _01466_ sky130_fd_sc_hd__a21oi_1
X_07434_ _00466_ VSS VSS VDD VDD _01470_ sky130_fd_sc_hd__inv_1
X_07435_ _01456_ _00456_ VSS VSS VDD VDD _03631_ sky130_fd_sc_hd__nand2_1
X_07436_ net430 _01456_ _03631_ VSS VSS VDD VDD _01474_ sky130_fd_sc_hd__o21ai_0
X_07437_ _00473_ VSS VSS VDD VDD _01478_ sky130_fd_sc_hd__inv_1
X_07438_ stage3_in_r\[12\] VSS VSS VDD VDD _00148_ sky130_fd_sc_hd__inv_1
X_07439_ _01465_ _00462_ VSS VSS VDD VDD _03632_ sky130_fd_sc_hd__nand2_1
X_07440_ net429 _01465_ _03632_ VSS VSS VDD VDD _01484_ sky130_fd_sc_hd__o21ai_0
X_07441_ _00479_ VSS VSS VDD VDD _01488_ sky130_fd_sc_hd__inv_1
X_07442_ _02222_ _02249_ VSS VSS VDD VDD _03633_ sky130_fd_sc_hd__xor2_1
X_07443_ _00469_ _03633_ VSS VSS VDD VDD _03634_ sky130_fd_sc_hd__nand2_1
X_07444_ net430 _03633_ _03634_ VSS VSS VDD VDD _01495_ sky130_fd_sc_hd__o21ai_0
X_07445_ _00483_ VSS VSS VDD VDD _01499_ sky130_fd_sc_hd__inv_1
X_07446_ stage3_in_r\[13\] VSS VSS VDD VDD _00141_ sky130_fd_sc_hd__inv_1
X_07447_ _01483_ _00475_ VSS VSS VDD VDD _03635_ sky130_fd_sc_hd__nand2_1
X_07448_ net429 _01483_ _03635_ VSS VSS VDD VDD _01505_ sky130_fd_sc_hd__o21ai_0
X_07449_ _00489_ VSS VSS VDD VDD _01509_ sky130_fd_sc_hd__inv_1
X_07450_ net426 _02248_ VSS VSS VDD VDD _03636_ sky130_fd_sc_hd__xnor2_1
X_07451_ net434 _03636_ VSS VSS VDD VDD _03637_ sky130_fd_sc_hd__nor2_1
X_07452_ _02222_ _03637_ VSS VSS VDD VDD _03638_ sky130_fd_sc_hd__nand2_1
X_07453_ net430 _03637_ _03638_ VSS VSS VDD VDD _01513_ sky130_fd_sc_hd__o21ai_0
X_07454_ _00493_ VSS VSS VDD VDD _01518_ sky130_fd_sc_hd__inv_1
X_07455_ stage3_in_r\[14\] VSS VSS VDD VDD _00142_ sky130_fd_sc_hd__inv_1
X_07456_ _01482_ _01504_ VSS VSS VDD VDD _03639_ sky130_fd_sc_hd__xor2_1
X_07457_ _00485_ _03639_ VSS VSS VDD VDD _03640_ sky130_fd_sc_hd__nand2_1
X_07458_ net429 _03639_ _03640_ VSS VSS VDD VDD _01526_ sky130_fd_sc_hd__o21ai_0
X_07459_ _00497_ VSS VSS VDD VDD _01531_ sky130_fd_sc_hd__inv_1
X_07460_ _00272_ VSS VSS VDD VDD _01648_ sky130_fd_sc_hd__inv_1
X_07461_ _02277_ VSS VSS VDD VDD _00507_ sky130_fd_sc_hd__inv_1
X_07462_ _00529_ VSS VSS VDD VDD _00525_ sky130_fd_sc_hd__inv_1
X_07463_ _00532_ VSS VSS VDD VDD _01838_ sky130_fd_sc_hd__inv_1
X_07464_ _01837_ _03320_ _01836_ VSS VSS VDD VDD _03641_ sky130_fd_sc_hd__a21oi_1
X_07465_ _01833_ _03641_ VSS VSS VDD VDD _01851_ sky130_fd_sc_hd__xnor2_1
X_07466_ _01842_ _03319_ VSS VSS VDD VDD _01855_ sky130_fd_sc_hd__xnor2_1
X_07467_ _00537_ _01846_ VSS VSS VDD VDD _01858_ sky130_fd_sc_hd__xnor2_1
X_07468_ _00538_ VSS VSS VDD VDD _01862_ sky130_fd_sc_hd__inv_1
X_07469_ _02298_ VSS VSS VDD VDD _00539_ sky130_fd_sc_hd__inv_1
X_07470_ _00987_ VSS VSS VDD VDD _00549_ sky130_fd_sc_hd__inv_1
X_07471_ _00546_ VSS VSS VDD VDD _01889_ sky130_fd_sc_hd__inv_1
X_07472_ _01003_ VSS VSS VDD VDD _00558_ sky130_fd_sc_hd__inv_1
X_07473_ _00555_ VSS VSS VDD VDD _01894_ sky130_fd_sc_hd__inv_1
X_07474_ _01019_ VSS VSS VDD VDD _00569_ sky130_fd_sc_hd__inv_1
X_07475_ _00564_ VSS VSS VDD VDD _00577_ sky130_fd_sc_hd__inv_1
X_07476_ _00566_ VSS VSS VDD VDD _01899_ sky130_fd_sc_hd__inv_1
X_07477_ _00575_ VSS VSS VDD VDD _00587_ sky130_fd_sc_hd__inv_1
X_07478_ _00593_ VSS VSS VDD VDD _00594_ sky130_fd_sc_hd__inv_1
X_07479_ _00585_ VSS VSS VDD VDD _00602_ sky130_fd_sc_hd__inv_1
X_07480_ _00600_ VSS VSS VDD VDD _00611_ sky130_fd_sc_hd__inv_1
X_07481_ _01925_ VSS VSS VDD VDD _01938_ sky130_fd_sc_hd__inv_1
X_07482_ _01940_ VSS VSS VDD VDD _00613_ sky130_fd_sc_hd__inv_1
X_07483_ _00609_ VSS VSS VDD VDD _00621_ sky130_fd_sc_hd__inv_1
X_07484_ _00619_ VSS VSS VDD VDD _00630_ sky130_fd_sc_hd__inv_1
X_07485_ _00628_ VSS VSS VDD VDD _00640_ sky130_fd_sc_hd__inv_1
X_07486_ _00638_ VSS VSS VDD VDD _00645_ sky130_fd_sc_hd__inv_1
X_07487_ _01956_ _03427_ VSS VSS VDD VDD _01957_ sky130_fd_sc_hd__xor2_1
X_07488_ _01952_ VSS VSS VDD VDD _03642_ sky130_fd_sc_hd__inv_1
X_07489_ _03642_ _03420_ _01951_ VSS VSS VDD VDD _03643_ sky130_fd_sc_hd__o21bai_1
X_07490_ _01956_ _03643_ _01955_ VSS VSS VDD VDD _03644_ sky130_fd_sc_hd__a21oi_1
X_07491_ _01962_ _03644_ VSS VSS VDD VDD _01963_ sky130_fd_sc_hd__xnor2_1
X_07492_ stage3_in_r\[23\] VSS VSS VDD VDD _00042_ sky130_fd_sc_hd__inv_2
X_07493_ _01382_ VSS VSS VDD VDD _00394_ sky130_fd_sc_hd__inv_1
X_07494_ stage3_in_r\[22\] VSS VSS VDD VDD _00034_ sky130_fd_sc_hd__inv_2
X_07495_ stage3_in_r\[20\] VSS VSS VDD VDD _00082_ sky130_fd_sc_hd__inv_1
X_07496_ _00669_ VSS VSS VDD VDD _02029_ sky130_fd_sc_hd__inv_1
X_07497_ stage3_in_r\[19\] VSS VSS VDD VDD _00091_ sky130_fd_sc_hd__inv_1
X_07498_ _00305_ VSS VSS VDD VDD _02030_ sky130_fd_sc_hd__inv_1
X_07499_ _00674_ VSS VSS VDD VDD _00670_ sky130_fd_sc_hd__inv_1
X_07500_ _00677_ VSS VSS VDD VDD _02042_ sky130_fd_sc_hd__inv_1
X_07501_ stage3_in_r\[65\] VSS VSS VDD VDD _02052_ sky130_fd_sc_hd__inv_1
X_07502_ stage3_in_r\[64\] VSS VSS VDD VDD _00679_ sky130_fd_sc_hd__inv_1
X_07503_ _00698_ VSS VSS VDD VDD _02056_ sky130_fd_sc_hd__inv_1
X_07504_ _00714_ VSS VSS VDD VDD _00708_ sky130_fd_sc_hd__inv_1
X_07505_ _00741_ VSS VSS VDD VDD _02064_ sky130_fd_sc_hd__inv_1
X_07506_ _00736_ VSS VSS VDD VDD _02069_ sky130_fd_sc_hd__inv_1
X_07507_ _00761_ VSS VSS VDD VDD _00756_ sky130_fd_sc_hd__inv_1
X_07508_ _00772_ VSS VSS VDD VDD _00768_ sky130_fd_sc_hd__inv_1
X_07509_ _00782_ VSS VSS VDD VDD _02076_ sky130_fd_sc_hd__inv_1
X_07510_ _00790_ VSS VSS VDD VDD _02079_ sky130_fd_sc_hd__inv_1
X_07511_ _00754_ VSS VSS VDD VDD _02080_ sky130_fd_sc_hd__inv_1
X_07512_ _00797_ VSS VSS VDD VDD _00793_ sky130_fd_sc_hd__inv_1
X_07513_ _00808_ VSS VSS VDD VDD _02100_ sky130_fd_sc_hd__inv_1
X_07514_ _00804_ VSS VSS VDD VDD _02105_ sky130_fd_sc_hd__inv_1
X_07515_ _00813_ VSS VSS VDD VDD _02107_ sky130_fd_sc_hd__inv_1
X_07516_ _02067_ _03574_ VSS VSS VDD VDD _02118_ sky130_fd_sc_hd__xnor2_1
X_07517_ stage3_in_r\[24\] VSS VSS VDD VDD _00025_ sky130_fd_sc_hd__inv_1
X_07518_ _01405_ VSS VSS VDD VDD _00415_ sky130_fd_sc_hd__inv_1
X_07519_ net455 VSS VSS VDD VDD _02177_ sky130_fd_sc_hd__inv_1
X_07520_ _00725_ VSS VSS VDD VDD _02180_ sky130_fd_sc_hd__inv_1
X_07521_ _03519_ _03520_ _03521_ VSS VSS VDD VDD _03645_ sky130_fd_sc_hd__a21oi_1
X_07522_ _02183_ _03645_ VSS VSS VDD VDD _02184_ sky130_fd_sc_hd__xnor2_1
X_07523_ stage3_in_r\[25\] VSS VSS VDD VDD _00026_ sky130_fd_sc_hd__inv_2
X_07524_ _00436_ VSS VSS VDD VDD _00847_ sky130_fd_sc_hd__inv_1
X_07525_ _00830_ VSS VSS VDD VDD _02189_ sky130_fd_sc_hd__inv_1
X_07526_ stage3_in_r\[67\] VSS VSS VDD VDD _00776_ sky130_fd_sc_hd__inv_1
X_07527_ _00844_ VSS VSS VDD VDD _02198_ sky130_fd_sc_hd__inv_1
X_07528_ _02067_ _03574_ _02066_ VSS VSS VDD VDD _03646_ sky130_fd_sc_hd__a21o_1
X_07529_ _02183_ _03646_ _02182_ VSS VSS VDD VDD _03647_ sky130_fd_sc_hd__a21oi_1
X_07530_ _02201_ _03647_ VSS VSS VDD VDD _02202_ sky130_fd_sc_hd__xor2_1
X_07531_ stage3_in_r\[26\] VSS VSS VDD VDD _00027_ sky130_fd_sc_hd__inv_1
X_07532_ _00455_ VSS VSS VDD VDD _00870_ sky130_fd_sc_hd__inv_1
X_07533_ _00853_ VSS VSS VDD VDD _02207_ sky130_fd_sc_hd__inv_1
X_07534_ stage3_in_r\[68\] VSS VSS VDD VDD _00765_ sky130_fd_sc_hd__inv_1
X_07535_ net427 _01937_ _03499_ VSS VSS VDD VDD _02211_ sky130_fd_sc_hd__o21ai_0
X_07536_ _00867_ VSS VSS VDD VDD _02214_ sky130_fd_sc_hd__inv_1
X_07537_ _02183_ _03645_ VSS VSS VDD VDD _03648_ sky130_fd_sc_hd__and2_1
X_07538_ _02182_ _03648_ _02201_ VSS VSS VDD VDD _03649_ sky130_fd_sc_hd__o21ai_0
X_07539_ _02217_ _02200_ VSS VSS VDD VDD _03650_ sky130_fd_sc_hd__nor2_1
X_07540_ _03649_ _03650_ _03526_ _03523_ VSS VSS VDD VDD _02218_
+ sky130_fd_sc_hd__a211o_1
X_07541_ stage3_in_r\[27\] VSS VSS VDD VDD _00059_ sky130_fd_sc_hd__inv_1
X_07542_ _00468_ VSS VSS VDD VDD _00892_ sky130_fd_sc_hd__inv_1
X_07543_ _00876_ VSS VSS VDD VDD _00900_ sky130_fd_sc_hd__inv_1
X_07544_ _00878_ VSS VSS VDD VDD _02224_ sky130_fd_sc_hd__inv_1
X_07545_ stage3_in_r\[69\] VSS VSS VDD VDD _00748_ sky130_fd_sc_hd__inv_1
X_07546_ _00860_ VSS VSS VDD VDD _02231_ sky130_fd_sc_hd__inv_1
X_07547_ _00889_ VSS VSS VDD VDD _02235_ sky130_fd_sc_hd__inv_1
X_07548_ _03574_ _03575_ _03578_ _02200_ VSS VSS VDD VDD _03651_
+ sky130_fd_sc_hd__a211o_1
X_07549_ _02217_ _03651_ _02216_ VSS VSS VDD VDD _03652_ sky130_fd_sc_hd__a21oi_1
X_07550_ _02238_ _03652_ VSS VSS VDD VDD _02239_ sky130_fd_sc_hd__xor2_1
X_07551_ _00910_ VSS VSS VDD VDD _02259_ sky130_fd_sc_hd__inv_1
X_07552_ _00926_ VSS VSS VDD VDD _02278_ sky130_fd_sc_hd__inv_1
X_07553_ _00931_ VSS VSS VDD VDD _02281_ sky130_fd_sc_hd__inv_1
X_07554_ _02284_ VSS VSS VDD VDD _03653_ sky130_fd_sc_hd__inv_1
X_07555_ _03580_ _03583_ VSS VSS VDD VDD _03654_ sky130_fd_sc_hd__nor2_1
X_07556_ _02262_ _03654_ _02261_ VSS VSS VDD VDD _03655_ sky130_fd_sc_hd__a21oi_1
X_07557_ _03653_ _03655_ VSS VSS VDD VDD _02285_ sky130_fd_sc_hd__xnor2_1
X_07558_ _00943_ VSS VSS VDD VDD _00964_ sky130_fd_sc_hd__inv_1
X_07559_ stage3_in_r\[72\] VSS VSS VDD VDD _00702_ sky130_fd_sc_hd__inv_1
X_07560_ _00948_ VSS VSS VDD VDD _00969_ sky130_fd_sc_hd__inv_1
X_07561_ _00950_ VSS VSS VDD VDD _02299_ sky130_fd_sc_hd__inv_1
X_07562_ _00955_ VSS VSS VDD VDD _02301_ sky130_fd_sc_hd__inv_1
X_07563_ _03653_ _03548_ VSS VSS VDD VDD _03656_ sky130_fd_sc_hd__nor2_1
X_07564_ _02283_ _03656_ VSS VSS VDD VDD _03657_ sky130_fd_sc_hd__nor2_1
X_07565_ _02304_ _03657_ VSS VSS VDD VDD _02305_ sky130_fd_sc_hd__xor2_1
X_07566_ _01133_ VSS VSS VDD VDD _02314_ sky130_fd_sc_hd__inv_1
X_07567_ _02316_ VSS VSS VDD VDD _00977_ sky130_fd_sc_hd__inv_1
X_07568_ _00962_ VSS VSS VDD VDD _00985_ sky130_fd_sc_hd__inv_1
X_07569_ stage3_in_r\[73\] VSS VSS VDD VDD _00703_ sky130_fd_sc_hd__inv_1
X_07570_ _00973_ VSS VSS VDD VDD _02324_ sky130_fd_sc_hd__inv_1
X_07571_ _03653_ _03655_ _02283_ VSS VSS VDD VDD _03658_ sky130_fd_sc_hd__o21bai_1
X_07572_ _02304_ _03658_ _02303_ VSS VSS VDD VDD _03659_ sky130_fd_sc_hd__a21oi_1
X_07573_ _02327_ _03659_ VSS VSS VDD VDD _02328_ sky130_fd_sc_hd__xor2_1
X_07574_ _00983_ VSS VSS VDD VDD _01001_ sky130_fd_sc_hd__inv_1
X_07575_ stage3_in_r\[74\] VSS VSS VDD VDD _00704_ sky130_fd_sc_hd__inv_1
X_07576_ net447 _02320_ VSS VSS VDD VDD _03660_ sky130_fd_sc_hd__nor2_1
X_07577_ _00967_ _02320_ _03660_ VSS VSS VDD VDD _02338_ sky130_fd_sc_hd__a21oi_1
X_07578_ _00992_ VSS VSS VDD VDD _02342_ sky130_fd_sc_hd__inv_1
X_07579_ _00999_ VSS VSS VDD VDD _01017_ sky130_fd_sc_hd__inv_1
X_07580_ stage3_in_r\[75\] VSS VSS VDD VDD _00735_ sky130_fd_sc_hd__inv_1
X_07581_ _02337_ _00988_ VSS VSS VDD VDD _03661_ sky130_fd_sc_hd__nand2_1
X_07582_ net427 _02337_ _03661_ VSS VSS VDD VDD _02354_ sky130_fd_sc_hd__o21ai_0
X_07583_ _01008_ VSS VSS VDD VDD _02358_ sky130_fd_sc_hd__inv_1
X_07584_ _02344_ _03588_ VSS VSS VDD VDD _03662_ sky130_fd_sc_hd__nor2_1
X_07585_ _02361_ _03662_ VSS VSS VDD VDD _02362_ sky130_fd_sc_hd__xor2_1
X_07586_ _01015_ VSS VSS VDD VDD _01029_ sky130_fd_sc_hd__inv_1
X_07587_ stage3_in_r\[76\] VSS VSS VDD VDD _00632_ sky130_fd_sc_hd__inv_1
X_07588_ _02353_ _01004_ VSS VSS VDD VDD _03663_ sky130_fd_sc_hd__nand2_1
X_07589_ net427 _02353_ _03663_ VSS VSS VDD VDD _02370_ sky130_fd_sc_hd__o21ai_0
X_07590_ _01024_ VSS VSS VDD VDD _02374_ sky130_fd_sc_hd__inv_1
X_07591_ _02345_ _03584_ VSS VSS VDD VDD _03664_ sky130_fd_sc_hd__nand2_1
X_07592_ _03548_ _03664_ VSS VSS VDD VDD _03665_ sky130_fd_sc_hd__nor2_1
X_07593_ _02344_ _03586_ _03665_ _02361_ VSS VSS VDD VDD _03666_
+ sky130_fd_sc_hd__o31ai_1
X_07594_ _02360_ _03666_ VSS VSS VDD VDD _03667_ sky130_fd_sc_hd__nor2b_1
X_07595_ _02377_ _03667_ VSS VSS VDD VDD _02378_ sky130_fd_sc_hd__xor2_1
X_07596_ _02352_ _02369_ VSS VSS VDD VDD _03668_ sky130_fd_sc_hd__xor2_1
X_07597_ _01020_ _03668_ VSS VSS VDD VDD _03669_ sky130_fd_sc_hd__nand2_1
X_07598_ net427 _03668_ _03669_ VSS VSS VDD VDD _02386_ sky130_fd_sc_hd__o21ai_0
X_07599_ _01041_ VSS VSS VDD VDD _02390_ sky130_fd_sc_hd__inv_1
X_07600_ _02393_ _03592_ VSS VSS VDD VDD _02394_ sky130_fd_sc_hd__xor2_1
X_07601_ _01036_ VSS VSS VDD VDD _02398_ sky130_fd_sc_hd__inv_1
X_07602_ net447 _02368_ VSS VSS VDD VDD _03670_ sky130_fd_sc_hd__xnor2_1
X_07603_ stage3_in_r\[77\] _03670_ VSS VSS VDD VDD _03671_
+ sky130_fd_sc_hd__nor2_1
X_07604_ _01926_ _03671_ VSS VSS VDD VDD _02401_ sky130_fd_sc_hd__xnor2_1
X_07605_ _01045_ VSS VSS VDD VDD _02406_ sky130_fd_sc_hd__inv_1
X_07606_ _02335_ _03542_ VSS VSS VDD VDD _03672_ sky130_fd_sc_hd__nor2b_1
X_07607_ _03539_ _03540_ _03672_ VSS VSS VDD VDD _03673_ sky130_fd_sc_hd__o21ai_0
X_07608_ _02336_ _02335_ _02351_ VSS VSS VDD VDD _03674_ sky130_fd_sc_hd__o21a_1
X_07609_ _03673_ _03674_ _02350_ _02366_ _02383_ VSS VSS VDD
+ VDD _03675_ sky130_fd_sc_hd__a2111oi_0
X_07610_ _02367_ _02366_ _02383_ VSS VSS VDD VDD _03676_ sky130_fd_sc_hd__nor3_1
X_07611_ _03596_ _03675_ _03676_ VSS VSS VDD VDD _03677_ sky130_fd_sc_hd__nor3_1
X_07612_ _02400_ _03677_ VSS VSS VDD VDD _02410_ sky130_fd_sc_hd__xor2_1
X_07613_ stage3_in_r\[113\] VSS VSS VDD VDD _01089_ sky130_fd_sc_hd__inv_1
X_07614_ stage3_in_r\[114\] VSS VSS VDD VDD _02471_ sky130_fd_sc_hd__inv_1
X_07615_ stage3_in_r\[115\] VSS VSS VDD VDD _02475_ sky130_fd_sc_hd__inv_1
X_07616_ stage3_in_r\[116\] VSS VSS VDD VDD _02479_ sky130_fd_sc_hd__inv_1
X_07617_ stage3_in_r\[117\] VSS VSS VDD VDD _02483_ sky130_fd_sc_hd__inv_1
X_07618_ stage3_in_r\[118\] VSS VSS VDD VDD _02487_ sky130_fd_sc_hd__inv_1
X_07619_ stage3_in_r\[119\] VSS VSS VDD VDD _02491_ sky130_fd_sc_hd__inv_1
X_07620_ stage3_in_r\[120\] VSS VSS VDD VDD _02495_ sky130_fd_sc_hd__inv_1
X_07621_ stage3_in_r\[121\] VSS VSS VDD VDD _02499_ sky130_fd_sc_hd__inv_1
X_07622_ stage3_in_r\[122\] VSS VSS VDD VDD _02503_ sky130_fd_sc_hd__inv_1
X_07623_ stage3_in_r\[123\] VSS VSS VDD VDD _02507_ sky130_fd_sc_hd__inv_1
X_07624_ stage3_in_r\[124\] VSS VSS VDD VDD _02511_ sky130_fd_sc_hd__inv_1
X_07625_ stage3_in_r\[125\] VSS VSS VDD VDD _02515_ sky130_fd_sc_hd__inv_1
X_07626_ stage3_in_r\[126\] VSS VSS VDD VDD _02519_ sky130_fd_sc_hd__inv_1
X_07627_ stage3_in_r\[127\] VSS VSS VDD VDD _02523_ sky130_fd_sc_hd__inv_1
X_07628_ stage2_in_r\[49\] VSS VSS VDD VDD _01081_ sky130_fd_sc_hd__inv_1
X_07629_ stage2_in_r\[50\] VSS VSS VDD VDD _02533_ sky130_fd_sc_hd__inv_1
X_07630_ stage2_in_r\[51\] VSS VSS VDD VDD _02537_ sky130_fd_sc_hd__inv_1
X_07631_ stage2_in_r\[52\] VSS VSS VDD VDD _02541_ sky130_fd_sc_hd__inv_1
X_07632_ stage2_in_r\[53\] VSS VSS VDD VDD _02545_ sky130_fd_sc_hd__inv_1
X_07633_ stage2_in_r\[54\] VSS VSS VDD VDD _02549_ sky130_fd_sc_hd__inv_1
X_07634_ stage2_in_r\[55\] VSS VSS VDD VDD _02553_ sky130_fd_sc_hd__inv_1
X_07635_ stage2_in_r\[56\] VSS VSS VDD VDD _02557_ sky130_fd_sc_hd__inv_1
X_07636_ stage2_in_r\[57\] VSS VSS VDD VDD _02561_ sky130_fd_sc_hd__inv_1
X_07637_ stage2_in_r\[58\] VSS VSS VDD VDD _02565_ sky130_fd_sc_hd__inv_1
X_07638_ stage2_in_r\[59\] VSS VSS VDD VDD _02569_ sky130_fd_sc_hd__inv_1
X_07639_ stage2_in_r\[60\] VSS VSS VDD VDD _02573_ sky130_fd_sc_hd__inv_1
X_07640_ stage2_in_r\[61\] VSS VSS VDD VDD _02577_ sky130_fd_sc_hd__inv_1
X_07641_ stage2_in_r\[62\] VSS VSS VDD VDD _02581_ sky130_fd_sc_hd__inv_1
X_07642_ stage2_in_r\[63\] VSS VSS VDD VDD _02585_ sky130_fd_sc_hd__inv_1
X_07643_ stage2_in_r\[177\] VSS VSS VDD VDD _01072_ sky130_fd_sc_hd__inv_1
X_07644_ stage2_in_r\[178\] VSS VSS VDD VDD _02595_ sky130_fd_sc_hd__inv_1
X_07645_ stage2_in_r\[179\] VSS VSS VDD VDD _02599_ sky130_fd_sc_hd__inv_1
X_07646_ stage2_in_r\[180\] VSS VSS VDD VDD _02603_ sky130_fd_sc_hd__inv_1
X_07647_ stage2_in_r\[181\] VSS VSS VDD VDD _02607_ sky130_fd_sc_hd__inv_1
X_07648_ stage2_in_r\[182\] VSS VSS VDD VDD _02611_ sky130_fd_sc_hd__inv_1
X_07649_ stage2_in_r\[183\] VSS VSS VDD VDD _02615_ sky130_fd_sc_hd__inv_1
X_07650_ stage2_in_r\[184\] VSS VSS VDD VDD _02619_ sky130_fd_sc_hd__inv_1
X_07651_ stage2_in_r\[185\] VSS VSS VDD VDD _02623_ sky130_fd_sc_hd__inv_1
X_07652_ stage2_in_r\[186\] VSS VSS VDD VDD _02627_ sky130_fd_sc_hd__inv_1
X_07653_ stage2_in_r\[187\] VSS VSS VDD VDD _02631_ sky130_fd_sc_hd__inv_1
X_07654_ stage2_in_r\[188\] VSS VSS VDD VDD _02635_ sky130_fd_sc_hd__inv_1
X_07655_ stage2_in_r\[189\] VSS VSS VDD VDD _02639_ sky130_fd_sc_hd__inv_1
X_07656_ stage2_in_r\[190\] VSS VSS VDD VDD _02643_ sky130_fd_sc_hd__inv_1
X_07657_ stage2_in_r\[191\] VSS VSS VDD VDD _02647_ sky130_fd_sc_hd__inv_1
X_07658_ stage1_in_r\[17\] VSS VSS VDD VDD _01068_ sky130_fd_sc_hd__inv_1
X_07659_ stage1_in_r\[18\] VSS VSS VDD VDD _02654_ sky130_fd_sc_hd__inv_1
X_07660_ stage1_in_r\[19\] VSS VSS VDD VDD _02658_ sky130_fd_sc_hd__inv_1
X_07661_ stage1_in_r\[20\] VSS VSS VDD VDD _02662_ sky130_fd_sc_hd__inv_1
X_07662_ stage1_in_r\[21\] VSS VSS VDD VDD _02666_ sky130_fd_sc_hd__inv_1
X_07663_ stage1_in_r\[22\] VSS VSS VDD VDD _02670_ sky130_fd_sc_hd__inv_1
X_07664_ stage1_in_r\[23\] VSS VSS VDD VDD _02674_ sky130_fd_sc_hd__inv_1
X_07665_ stage1_in_r\[24\] VSS VSS VDD VDD _02678_ sky130_fd_sc_hd__inv_1
X_07666_ stage1_in_r\[25\] VSS VSS VDD VDD _02682_ sky130_fd_sc_hd__inv_1
X_07667_ stage1_in_r\[26\] VSS VSS VDD VDD _02686_ sky130_fd_sc_hd__inv_1
X_07668_ stage1_in_r\[27\] VSS VSS VDD VDD _02690_ sky130_fd_sc_hd__inv_1
X_07669_ stage1_in_r\[28\] VSS VSS VDD VDD _02694_ sky130_fd_sc_hd__inv_1
X_07670_ stage1_in_r\[29\] VSS VSS VDD VDD _02698_ sky130_fd_sc_hd__inv_1
X_07671_ stage1_in_r\[30\] VSS VSS VDD VDD _02702_ sky130_fd_sc_hd__inv_1
X_07672_ stage1_in_r\[31\] VSS VSS VDD VDD _02706_ sky130_fd_sc_hd__inv_1
X_07673_ stage1_in_r\[81\] VSS VSS VDD VDD _01059_ sky130_fd_sc_hd__inv_1
X_07674_ stage1_in_r\[82\] VSS VSS VDD VDD _02713_ sky130_fd_sc_hd__inv_1
X_07675_ stage1_in_r\[83\] VSS VSS VDD VDD _02717_ sky130_fd_sc_hd__inv_1
X_07676_ stage1_in_r\[84\] VSS VSS VDD VDD _02721_ sky130_fd_sc_hd__inv_1
X_07677_ stage1_in_r\[85\] VSS VSS VDD VDD _02725_ sky130_fd_sc_hd__inv_1
X_07678_ stage1_in_r\[86\] VSS VSS VDD VDD _02729_ sky130_fd_sc_hd__inv_1
X_07679_ stage1_in_r\[87\] VSS VSS VDD VDD _02733_ sky130_fd_sc_hd__inv_1
X_07680_ stage1_in_r\[88\] VSS VSS VDD VDD _02737_ sky130_fd_sc_hd__inv_1
X_07681_ stage1_in_r\[89\] VSS VSS VDD VDD _02741_ sky130_fd_sc_hd__inv_1
X_07682_ stage1_in_r\[90\] VSS VSS VDD VDD _02745_ sky130_fd_sc_hd__inv_1
X_07683_ stage1_in_r\[91\] VSS VSS VDD VDD _02749_ sky130_fd_sc_hd__inv_1
X_07684_ stage1_in_r\[92\] VSS VSS VDD VDD _02753_ sky130_fd_sc_hd__inv_1
X_07685_ stage1_in_r\[93\] VSS VSS VDD VDD _02757_ sky130_fd_sc_hd__inv_1
X_07686_ stage1_in_r\[94\] VSS VSS VDD VDD _02761_ sky130_fd_sc_hd__inv_1
X_07687_ stage1_in_r\[95\] VSS VSS VDD VDD _02765_ sky130_fd_sc_hd__inv_1
X_07688_ stage1_in_r\[145\] VSS VSS VDD VDD _01055_ sky130_fd_sc_hd__inv_1
X_07689_ stage1_in_r\[146\] VSS VSS VDD VDD _02772_ sky130_fd_sc_hd__inv_1
X_07690_ stage1_in_r\[147\] VSS VSS VDD VDD _02776_ sky130_fd_sc_hd__inv_1
X_07691_ stage1_in_r\[148\] VSS VSS VDD VDD _02780_ sky130_fd_sc_hd__inv_1
X_07692_ stage1_in_r\[149\] VSS VSS VDD VDD _02784_ sky130_fd_sc_hd__inv_1
X_07693_ stage1_in_r\[150\] VSS VSS VDD VDD _02788_ sky130_fd_sc_hd__inv_1
X_07694_ stage1_in_r\[151\] VSS VSS VDD VDD _02792_ sky130_fd_sc_hd__inv_1
X_07695_ stage1_in_r\[152\] VSS VSS VDD VDD _02796_ sky130_fd_sc_hd__inv_1
X_07696_ stage1_in_r\[153\] VSS VSS VDD VDD _02800_ sky130_fd_sc_hd__inv_1
X_07697_ stage1_in_r\[154\] VSS VSS VDD VDD _02804_ sky130_fd_sc_hd__inv_1
X_07698_ stage1_in_r\[155\] VSS VSS VDD VDD _02808_ sky130_fd_sc_hd__inv_1
X_07699_ stage1_in_r\[156\] VSS VSS VDD VDD _02812_ sky130_fd_sc_hd__inv_1
X_07700_ stage1_in_r\[157\] VSS VSS VDD VDD _02816_ sky130_fd_sc_hd__inv_1
X_07701_ stage1_in_r\[158\] VSS VSS VDD VDD _02820_ sky130_fd_sc_hd__inv_1
X_07702_ stage1_in_r\[159\] VSS VSS VDD VDD _02824_ sky130_fd_sc_hd__inv_1
X_07703_ stage1_in_r\[210\] VSS VSS VDD VDD _02831_ sky130_fd_sc_hd__inv_1
X_07704_ stage1_in_r\[211\] VSS VSS VDD VDD _02835_ sky130_fd_sc_hd__inv_1
X_07705_ stage1_in_r\[212\] VSS VSS VDD VDD _02839_ sky130_fd_sc_hd__inv_1
X_07706_ stage1_in_r\[213\] VSS VSS VDD VDD _02843_ sky130_fd_sc_hd__inv_1
X_07707_ stage1_in_r\[214\] VSS VSS VDD VDD _02847_ sky130_fd_sc_hd__inv_1
X_07708_ stage1_in_r\[215\] VSS VSS VDD VDD _02851_ sky130_fd_sc_hd__inv_1
X_07709_ stage1_in_r\[216\] VSS VSS VDD VDD _02855_ sky130_fd_sc_hd__inv_1
X_07710_ stage1_in_r\[217\] VSS VSS VDD VDD _02859_ sky130_fd_sc_hd__inv_1
X_07711_ stage1_in_r\[218\] VSS VSS VDD VDD _02863_ sky130_fd_sc_hd__inv_1
X_07712_ stage1_in_r\[219\] VSS VSS VDD VDD _02867_ sky130_fd_sc_hd__inv_1
X_07713_ stage1_in_r\[220\] VSS VSS VDD VDD _02871_ sky130_fd_sc_hd__inv_1
X_07714_ stage1_in_r\[221\] VSS VSS VDD VDD _02875_ sky130_fd_sc_hd__inv_1
X_07715_ stage1_in_r\[222\] VSS VSS VDD VDD _02879_ sky130_fd_sc_hd__inv_1
X_07716_ stage1_in_r\[223\] VSS VSS VDD VDD _02883_ sky130_fd_sc_hd__inv_1
X_07717_ stage3_in_r\[49\] VSS VSS VDD VDD _01127_ sky130_fd_sc_hd__inv_1
X_07718_ _00022_ VSS VSS VDD VDD _01138_ sky130_fd_sc_hd__inv_1
X_07719_ _00038_ VSS VSS VDD VDD _00054_ sky130_fd_sc_hd__inv_1
X_07720_ _00050_ VSS VSS VDD VDD _01145_ sky130_fd_sc_hd__inv_1
X_07721_ _00070_ VSS VSS VDD VDD _01150_ sky130_fd_sc_hd__inv_1
X_07722_ _00081_ VSS VSS VDD VDD _01154_ sky130_fd_sc_hd__inv_1
X_07723_ _00019_ VSS VSS VDD VDD _00023_ sky130_fd_sc_hd__inv_1
X_07724_ _00076_ VSS VSS VDD VDD _01157_ sky130_fd_sc_hd__inv_1
X_07725_ _00041_ VSS VSS VDD VDD _00039_ sky130_fd_sc_hd__inv_1
X_07726_ _00088_ VSS VSS VDD VDD _00099_ sky130_fd_sc_hd__inv_1
X_07727_ _00057_ VSS VSS VDD VDD _00055_ sky130_fd_sc_hd__inv_1
X_07728_ _00065_ VSS VSS VDD VDD _01168_ sky130_fd_sc_hd__inv_1
X_07729_ _00098_ VSS VSS VDD VDD _01172_ sky130_fd_sc_hd__inv_1
X_07730_ _00068_ VSS VSS VDD VDD _01141_ sky130_fd_sc_hd__inv_1
X_07731_ _00109_ VSS VSS VDD VDD _01179_ sky130_fd_sc_hd__inv_1
X_07732_ _00079_ VSS VSS VDD VDD _01148_ sky130_fd_sc_hd__inv_1
X_07733_ _00121_ VSS VSS VDD VDD _00122_ sky130_fd_sc_hd__inv_1
X_07734_ _00092_ VSS VSS VDD VDD _00089_ sky130_fd_sc_hd__inv_1
X_07735_ _00128_ VSS VSS VDD VDD _01194_ sky130_fd_sc_hd__inv_1
X_07736_ _00133_ VSS VSS VDD VDD _01197_ sky130_fd_sc_hd__inv_1
X_07737_ _00158_ VSS VSS VDD VDD _01210_ sky130_fd_sc_hd__inv_1
X_07738_ _00174_ VSS VSS VDD VDD _00188_ sky130_fd_sc_hd__inv_1
X_07739_ _00185_ VSS VSS VDD VDD _01216_ sky130_fd_sc_hd__inv_1
X_07740_ _00203_ VSS VSS VDD VDD _01221_ sky130_fd_sc_hd__inv_1
X_07741_ _00214_ VSS VSS VDD VDD _01225_ sky130_fd_sc_hd__inv_1
X_07742_ _00155_ VSS VSS VDD VDD _00160_ sky130_fd_sc_hd__inv_1
X_07743_ _00209_ VSS VSS VDD VDD _01226_ sky130_fd_sc_hd__inv_1
X_07744_ _00177_ VSS VSS VDD VDD _00175_ sky130_fd_sc_hd__inv_1
X_07745_ _00191_ VSS VSS VDD VDD _00189_ sky130_fd_sc_hd__inv_1
X_07746_ _00198_ VSS VSS VDD VDD _01236_ sky130_fd_sc_hd__inv_1
X_07747_ _00229_ VSS VSS VDD VDD _01240_ sky130_fd_sc_hd__inv_1
X_07748_ _00201_ VSS VSS VDD VDD _01212_ sky130_fd_sc_hd__inv_1
X_07749_ _00239_ VSS VSS VDD VDD _01248_ sky130_fd_sc_hd__inv_1
X_07750_ _00212_ VSS VSS VDD VDD _01219_ sky130_fd_sc_hd__inv_1
X_07751_ _00251_ VSS VSS VDD VDD _00252_ sky130_fd_sc_hd__inv_1
X_07752_ _00223_ VSS VSS VDD VDD _00220_ sky130_fd_sc_hd__inv_1
X_07753_ _00257_ VSS VSS VDD VDD _01264_ sky130_fd_sc_hd__inv_1
X_07754_ _00262_ VSS VSS VDD VDD _01267_ sky130_fd_sc_hd__inv_1
X_07755_ _00287_ VSS VSS VDD VDD _01288_ sky130_fd_sc_hd__inv_1
X_07756_ _00150_ VSS VSS VDD VDD _00159_ sky130_fd_sc_hd__inv_1
X_07757_ _00303_ VSS VSS VDD VDD _01295_ sky130_fd_sc_hd__inv_1
X_07758_ _00281_ VSS VSS VDD VDD _01303_ sky130_fd_sc_hd__inv_1
X_07759_ _00318_ VSS VSS VDD VDD _01306_ sky130_fd_sc_hd__inv_1
X_07760_ _00330_ VSS VSS VDD VDD _01316_ sky130_fd_sc_hd__inv_1
X_07761_ _00340_ VSS VSS VDD VDD _01323_ sky130_fd_sc_hd__inv_1
X_07762_ _00350_ VSS VSS VDD VDD _01330_ sky130_fd_sc_hd__inv_1
X_07763_ _00361_ VSS VSS VDD VDD _01342_ sky130_fd_sc_hd__inv_1
X_07764_ _00371_ VSS VSS VDD VDD _01349_ sky130_fd_sc_hd__inv_1
X_07765_ _00382_ VSS VSS VDD VDD _01362_ sky130_fd_sc_hd__inv_1
X_07766_ _00392_ VSS VSS VDD VDD _01373_ sky130_fd_sc_hd__inv_1
X_07767_ _00403_ VSS VSS VDD VDD _01387_ sky130_fd_sc_hd__inv_1
X_07768_ _00413_ VSS VSS VDD VDD _01396_ sky130_fd_sc_hd__inv_1
X_07769_ _00417_ VSS VSS VDD VDD _00419_ sky130_fd_sc_hd__inv_1
X_07770_ _00423_ VSS VSS VDD VDD _01409_ sky130_fd_sc_hd__inv_1
X_07771_ _00429_ VSS VSS VDD VDD _00430_ sky130_fd_sc_hd__inv_1
X_07772_ _00435_ VSS VSS VDD VDD _01417_ sky130_fd_sc_hd__inv_1
X_07773_ _00416_ _00438_ VSS VSS VDD VDD _03678_ sky130_fd_sc_hd__xnor2_1
X_07774_ net430 _03678_ VSS VSS VDD VDD _01426_ sky130_fd_sc_hd__xnor2_1
X_07775_ _00442_ VSS VSS VDD VDD _01430_ sky130_fd_sc_hd__inv_1
X_07776_ _00446_ VSS VSS VDD VDD _00448_ sky130_fd_sc_hd__inv_1
X_07777_ _00452_ VSS VSS VDD VDD _01436_ sky130_fd_sc_hd__inv_1
X_07778_ _00457_ _00437_ VSS VSS VDD VDD _03679_ sky130_fd_sc_hd__xnor2_1
X_07779_ net431 _03679_ VSS VSS VDD VDD _01441_ sky130_fd_sc_hd__xnor2_1
X_07780_ _00461_ VSS VSS VDD VDD _01445_ sky130_fd_sc_hd__inv_1
X_07781_ _00445_ _00463_ VSS VSS VDD VDD _03680_ sky130_fd_sc_hd__xnor2_1
X_07782_ net429 _03680_ VSS VSS VDD VDD _01449_ sky130_fd_sc_hd__xnor2_1
X_07783_ _00467_ VSS VSS VDD VDD _01453_ sky130_fd_sc_hd__inv_1
X_07784_ _00470_ _00456_ VSS VSS VDD VDD _03681_ sky130_fd_sc_hd__xnor2_1
X_07785_ net431 _03681_ VSS VSS VDD VDD _01458_ sky130_fd_sc_hd__xnor2_1
X_07786_ _00474_ VSS VSS VDD VDD _01462_ sky130_fd_sc_hd__inv_1
X_07787_ _00476_ _00462_ VSS VSS VDD VDD _03682_ sky130_fd_sc_hd__xnor2_1
X_07788_ net459 _03682_ VSS VSS VDD VDD _01467_ sky130_fd_sc_hd__xnor2_1
X_07789_ _00480_ VSS VSS VDD VDD _01471_ sky130_fd_sc_hd__inv_1
X_07790_ _00469_ _03633_ VSS VSS VDD VDD _01475_ sky130_fd_sc_hd__xor2_1
X_07791_ _00484_ VSS VSS VDD VDD _01479_ sky130_fd_sc_hd__inv_1
X_07792_ _00486_ _00475_ VSS VSS VDD VDD _03683_ sky130_fd_sc_hd__xnor2_1
X_07793_ net459 _03683_ VSS VSS VDD VDD _01485_ sky130_fd_sc_hd__xnor2_1
X_07794_ _00490_ VSS VSS VDD VDD _01489_ sky130_fd_sc_hd__inv_1
X_07795_ _02222_ net431 net434 VSS VSS VDD VDD _03684_ sky130_fd_sc_hd__mux2i_1
X_07796_ _03636_ _03684_ VSS VSS VDD VDD _01496_ sky130_fd_sc_hd__xor2_1
X_07797_ _00494_ VSS VSS VDD VDD _01500_ sky130_fd_sc_hd__inv_1
X_07798_ _00485_ _03639_ VSS VSS VDD VDD _01506_ sky130_fd_sc_hd__xor2_1
X_07799_ _00498_ VSS VSS VDD VDD _01510_ sky130_fd_sc_hd__inv_1
X_07800_ net431 _02248_ VSS VSS VDD VDD _03685_ sky130_fd_sc_hd__xnor2_1
X_07801_ net433 _03685_ VSS VSS VDD VDD _03686_ sky130_fd_sc_hd__nor2_1
X_07802_ _01493_ _03686_ VSS VSS VDD VDD _01514_ sky130_fd_sc_hd__xnor2_1
X_07803_ _00502_ VSS VSS VDD VDD _01519_ sky130_fd_sc_hd__inv_1
X_07804_ _01482_ net459 stage3_in_r\[13\] VSS VSS VDD VDD
+ _03687_ sky130_fd_sc_hd__mux2i_1
X_07805_ _03209_ _03687_ VSS VSS VDD VDD _01527_ sky130_fd_sc_hd__xor2_1
X_07806_ _00506_ VSS VSS VDD VDD _01532_ sky130_fd_sc_hd__inv_1
X_07807_ _03168_ _03171_ VSS VSS VDD VDD _01574_ sky130_fd_sc_hd__xnor2_1
X_07808_ _03182_ _03177_ VSS VSS VDD VDD _01579_ sky130_fd_sc_hd__xnor2_1
X_07809_ _03220_ _03186_ VSS VSS VDD VDD _01584_ sky130_fd_sc_hd__xnor2_1
X_07810_ _03221_ _03223_ _03226_ VSS VSS VDD VDD _01589_ sky130_fd_sc_hd__nor3_1
X_07811_ _01673_ VSS VSS VDD VDD _01670_ sky130_fd_sc_hd__inv_1
X_07812_ net421 VSS VSS VDD VDD _01721_ sky130_fd_sc_hd__inv_1
X_07813_ net413 _03280_ VSS VSS VDD VDD _01809_ sky130_fd_sc_hd__xor2_1
X_07814_ _00514_ VSS VSS VDD VDD _01821_ sky130_fd_sc_hd__inv_1
X_07815_ _00519_ VSS VSS VDD VDD _00522_ sky130_fd_sc_hd__inv_1
X_07816_ _00516_ VSS VSS VDD VDD _00521_ sky130_fd_sc_hd__inv_1
X_07817_ _00533_ VSS VSS VDD VDD _01843_ sky130_fd_sc_hd__inv_1
X_07818_ _01170_ _02917_ VSS VSS VDD VDD _01852_ sky130_fd_sc_hd__xor2_1
X_07819_ _01164_ _02914_ VSS VSS VDD VDD _01607_ sky130_fd_sc_hd__xnor2_2
X_07820_ _01183_ _01181_ _02939_ _02930_ VSS VSS VDD VDD _03688_
+ sky130_fd_sc_hd__a31oi_1
X_07821_ _01174_ _03688_ VSS VSS VDD VDD _01613_ sky130_fd_sc_hd__xnor2_1
X_07822_ _02905_ _02910_ VSS VSS VDD VDD _03689_ sky130_fd_sc_hd__nor2_1
X_07823_ _01181_ _03689_ VSS VSS VDD VDD _01619_ sky130_fd_sc_hd__xnor2_1
X_07824_ _01183_ _02939_ VSS VSS VDD VDD _01625_ sky130_fd_sc_hd__xor2_1
X_07825_ _02906_ _02908_ VSS VSS VDD VDD _03690_ sky130_fd_sc_hd__nand2_1
X_07826_ _01189_ _03690_ VSS VSS VDD VDD _01631_ sky130_fd_sc_hd__xor2_1
X_07827_ _01199_ _02934_ _01198_ VSS VSS VDD VDD _03691_ sky130_fd_sc_hd__a21oi_1
X_07828_ _01196_ _03691_ VSS VSS VDD VDD _01637_ sky130_fd_sc_hd__xnor2_1
X_07829_ _00266_ _01199_ VSS VSS VDD VDD _01643_ sky130_fd_sc_hd__xnor2_1
X_07830_ _00267_ VSS VSS VDD VDD _01649_ sky130_fd_sc_hd__inv_1
X_07831_ _00547_ VSS VSS VDD VDD _01885_ sky130_fd_sc_hd__inv_1
X_07832_ _00556_ VSS VSS VDD VDD _01890_ sky130_fd_sc_hd__inv_1
X_07833_ _00567_ VSS VSS VDD VDD _01895_ sky130_fd_sc_hd__inv_1
X_07834_ _00576_ VSS VSS VDD VDD _00578_ sky130_fd_sc_hd__inv_1
X_07835_ _00586_ VSS VSS VDD VDD _00588_ sky130_fd_sc_hd__inv_1
X_07836_ _00601_ VSS VSS VDD VDD _00603_ sky130_fd_sc_hd__inv_1
X_07837_ _00592_ VSS VSS VDD VDD _01927_ sky130_fd_sc_hd__inv_1
X_07838_ _00610_ VSS VSS VDD VDD _00612_ sky130_fd_sc_hd__inv_1
X_07839_ _00620_ VSS VSS VDD VDD _00622_ sky130_fd_sc_hd__inv_1
X_07840_ _00629_ VSS VSS VDD VDD _00631_ sky130_fd_sc_hd__inv_1
X_07841_ _00639_ VSS VSS VDD VDD _00641_ sky130_fd_sc_hd__inv_1
X_07842_ _00635_ VSS VSS VDD VDD _00642_ sky130_fd_sc_hd__inv_1
X_07843_ _00650_ VSS VSS VDD VDD _01954_ sky130_fd_sc_hd__inv_1
X_07844_ _01464_ _03159_ _01463_ VSS VSS VDD VDD _03692_ sky130_fd_sc_hd__a21o_1
X_07845_ _01481_ _03692_ _01480_ VSS VSS VDD VDD _03693_ sky130_fd_sc_hd__a21oi_1
X_07846_ _01502_ _03693_ VSS VSS VDD VDD _01756_ sky130_fd_sc_hd__xnor2_1
X_07847_ _00649_ VSS VSS VDD VDD _01960_ sky130_fd_sc_hd__inv_1
X_07848_ _01502_ VSS VSS VDD VDD _03694_ sky130_fd_sc_hd__inv_1
X_07849_ _01481_ _03170_ _01480_ VSS VSS VDD VDD _03695_ sky130_fd_sc_hd__a21oi_1
X_07850_ _03694_ _03695_ _01501_ VSS VSS VDD VDD _03696_ sky130_fd_sc_hd__o21ba_2
X_07851_ _01521_ _03696_ VSS VSS VDD VDD _01536_ sky130_fd_sc_hd__xnor2_1
X_07852_ _01965_ _03424_ VSS VSS VDD VDD _02012_ sky130_fd_sc_hd__xor2_1
X_07853_ _03431_ _03437_ VSS VSS VDD VDD _01966_ sky130_fd_sc_hd__xor2_1
X_07854_ _00657_ VSS VSS VDD VDD _02025_ sky130_fd_sc_hd__inv_1
X_07855_ _00014_ VSS VSS VDD VDD _00663_ sky130_fd_sc_hd__inv_1
X_07856_ _00662_ VSS VSS VDD VDD _00665_ sky130_fd_sc_hd__inv_1
X_07857_ _00659_ VSS VSS VDD VDD _00664_ sky130_fd_sc_hd__inv_1
X_07858_ _00668_ VSS VSS VDD VDD _02028_ sky130_fd_sc_hd__inv_1
X_07859_ _00678_ VSS VSS VDD VDD _02045_ sky130_fd_sc_hd__inv_1
X_07860_ _00699_ VSS VSS VDD VDD _02060_ sky130_fd_sc_hd__inv_1
X_07861_ _00715_ VSS VSS VDD VDD _00730_ sky130_fd_sc_hd__inv_1
X_07862_ _00726_ VSS VSS VDD VDD _02065_ sky130_fd_sc_hd__inv_1
X_07863_ _00696_ VSS VSS VDD VDD _00700_ sky130_fd_sc_hd__inv_1
X_07864_ _00755_ VSS VSS VDD VDD _02072_ sky130_fd_sc_hd__inv_1
X_07865_ _00718_ VSS VSS VDD VDD _00716_ sky130_fd_sc_hd__inv_1
X_07866_ _00773_ VSS VSS VDD VDD _00784_ sky130_fd_sc_hd__inv_1
X_07867_ _00733_ VSS VSS VDD VDD _00731_ sky130_fd_sc_hd__inv_1
X_07868_ _00742_ VSS VSS VDD VDD _02081_ sky130_fd_sc_hd__inv_1
X_07869_ _00783_ VSS VSS VDD VDD _02084_ sky130_fd_sc_hd__inv_1
X_07870_ _00749_ VSS VSS VDD VDD _00746_ sky130_fd_sc_hd__inv_1
X_07871_ _00766_ VSS VSS VDD VDD _00763_ sky130_fd_sc_hd__inv_1
X_07872_ _00798_ VSS VSS VDD VDD _00800_ sky130_fd_sc_hd__inv_1
X_07873_ _00777_ VSS VSS VDD VDD _00774_ sky130_fd_sc_hd__inv_1
X_07874_ _00809_ VSS VSS VDD VDD _02108_ sky130_fd_sc_hd__inv_1
X_07875_ _00814_ VSS VSS VDD VDD _02111_ sky130_fd_sc_hd__inv_1
X_07876_ _03511_ _03602_ VSS VSS VDD VDD _03697_ sky130_fd_sc_hd__nand2_1
X_07877_ _02032_ _03697_ VSS VSS VDD VDD _03698_ sky130_fd_sc_hd__nor2_1
X_07878_ _03603_ _03698_ VSS VSS VDD VDD _02119_ sky130_fd_sc_hd__nor2_1
X_07879_ _02037_ _03510_ VSS VSS VDD VDD _02123_ sky130_fd_sc_hd__xnor2_1
X_07880_ _03508_ _03600_ VSS VSS VDD VDD _03699_ sky130_fd_sc_hd__nand2_1
X_07881_ _02041_ _03699_ VSS VSS VDD VDD _03700_ sky130_fd_sc_hd__nor2_1
X_07882_ _03601_ _03700_ VSS VSS VDD VDD _02127_ sky130_fd_sc_hd__nor2_1
X_07883_ _02044_ _03507_ VSS VSS VDD VDD _02131_ sky130_fd_sc_hd__xnor2_1
X_07884_ _00818_ _02047_ VSS VSS VDD VDD _02135_ sky130_fd_sc_hd__xnor2_1
X_07885_ _00819_ VSS VSS VDD VDD _02140_ sky130_fd_sc_hd__inv_1
X_07886_ _00831_ VSS VSS VDD VDD _02174_ sky130_fd_sc_hd__inv_1
X_07887_ _00845_ VSS VSS VDD VDD _02181_ sky130_fd_sc_hd__inv_1
X_07888_ _02176_ _03513_ VSS VSS VDD VDD _02185_ sky130_fd_sc_hd__xnor2_1
X_07889_ _00854_ VSS VSS VDD VDD _02190_ sky130_fd_sc_hd__inv_1
X_07890_ _00840_ VSS VSS VDD VDD _02196_ sky130_fd_sc_hd__inv_1
X_07891_ _00868_ VSS VSS VDD VDD _02199_ sky130_fd_sc_hd__inv_1
X_07892_ _03514_ _03604_ VSS VSS VDD VDD _03701_ sky130_fd_sc_hd__nand2_1
X_07893_ _02192_ _03701_ VSS VSS VDD VDD _03702_ sky130_fd_sc_hd__nor2_1
X_07894_ _03605_ _03702_ VSS VSS VDD VDD _02203_ sky130_fd_sc_hd__nor2_1
X_07895_ _00879_ VSS VSS VDD VDD _02208_ sky130_fd_sc_hd__inv_1
X_07896_ _00890_ VSS VSS VDD VDD _02215_ sky130_fd_sc_hd__inv_1
X_07897_ _02210_ _03516_ VSS VSS VDD VDD _02219_ sky130_fd_sc_hd__xnor2_1
X_07898_ _00899_ VSS VSS VDD VDD _00901_ sky130_fd_sc_hd__inv_1
X_07899_ _00911_ VSS VSS VDD VDD _02236_ sky130_fd_sc_hd__inv_1
X_07900_ _02191_ _03605_ _02210_ VSS VSS VDD VDD _03703_ sky130_fd_sc_hd__o21ai_0
X_07901_ _02226_ _02209_ VSS VSS VDD VDD _03704_ sky130_fd_sc_hd__nor2_1
X_07902_ _03606_ _03607_ VSS VSS VDD VDD _03705_ sky130_fd_sc_hd__nor2_1
X_07903_ _03703_ _03704_ _03705_ VSS VSS VDD VDD _02240_ sky130_fd_sc_hd__a21oi_1
X_07904_ _00932_ VSS VSS VDD VDD _02260_ sky130_fd_sc_hd__inv_1
X_07905_ _00956_ VSS VSS VDD VDD _02282_ sky130_fd_sc_hd__inv_1
X_07906_ _02225_ _03705_ _02253_ VSS VSS VDD VDD _03706_ sky130_fd_sc_hd__o21ai_0
X_07907_ _02252_ _03706_ VSS VSS VDD VDD _03707_ sky130_fd_sc_hd__nand2b_1
X_07908_ _02275_ _03707_ VSS VSS VDD VDD _02286_ sky130_fd_sc_hd__xor2_1
X_07909_ _00935_ VSS VSS VDD VDD _02294_ sky130_fd_sc_hd__inv_1
X_07910_ _00963_ VSS VSS VDD VDD _00965_ sky130_fd_sc_hd__inv_1
X_07911_ _00968_ VSS VSS VDD VDD _00970_ sky130_fd_sc_hd__inv_1
X_07912_ _00974_ VSS VSS VDD VDD _02302_ sky130_fd_sc_hd__inv_1
X_07913_ _03539_ VSS VSS VDD VDD _03708_ sky130_fd_sc_hd__inv_1
X_07914_ _02275_ _03708_ _02274_ VSS VSS VDD VDD _03709_ sky130_fd_sc_hd__a21oi_1
X_07915_ _02297_ _03709_ VSS VSS VDD VDD _02306_ sky130_fd_sc_hd__xnor2_1
X_07916_ _00984_ VSS VSS VDD VDD _00986_ sky130_fd_sc_hd__inv_1
X_07917_ _00967_ _00989_ VSS VSS VDD VDD _03710_ sky130_fd_sc_hd__xnor2_1
X_07918_ net427 _03710_ VSS VSS VDD VDD _02321_ sky130_fd_sc_hd__xnor2_1
X_07919_ _00993_ VSS VSS VDD VDD _02325_ sky130_fd_sc_hd__inv_1
X_07920_ _02275_ _03707_ _02274_ VSS VSS VDD VDD _03711_ sky130_fd_sc_hd__a21o_1
X_07921_ _02297_ _03711_ _02296_ VSS VSS VDD VDD _03712_ sky130_fd_sc_hd__a21oi_1
X_07922_ _02319_ _03712_ VSS VSS VDD VDD _02329_ sky130_fd_sc_hd__xnor2_1
X_07923_ _01000_ VSS VSS VDD VDD _01002_ sky130_fd_sc_hd__inv_1
X_07924_ _01005_ _00988_ VSS VSS VDD VDD _03713_ sky130_fd_sc_hd__xnor2_1
X_07925_ net447 _03713_ VSS VSS VDD VDD _02339_ sky130_fd_sc_hd__xnor2_1
X_07926_ _01009_ VSS VSS VDD VDD _02343_ sky130_fd_sc_hd__inv_1
X_07927_ _01016_ VSS VSS VDD VDD _01018_ sky130_fd_sc_hd__inv_1
X_07928_ _01021_ _01004_ VSS VSS VDD VDD _03714_ sky130_fd_sc_hd__xnor2_1
X_07929_ net447 _03714_ VSS VSS VDD VDD _02355_ sky130_fd_sc_hd__xnor2_1
X_07930_ _01025_ VSS VSS VDD VDD _02359_ sky130_fd_sc_hd__inv_1
X_07931_ _02336_ _03609_ _03611_ _02335_ VSS VSS VDD VDD _03715_
+ sky130_fd_sc_hd__a31oi_1
X_07932_ _02351_ _03715_ VSS VSS VDD VDD _02363_ sky130_fd_sc_hd__xnor2_1
X_07933_ _01012_ VSS VSS VDD VDD _01026_ sky130_fd_sc_hd__inv_1
X_07934_ _01020_ _03668_ VSS VSS VDD VDD _02371_ sky130_fd_sc_hd__xor2_1
X_07935_ _01033_ VSS VSS VDD VDD _02375_ sky130_fd_sc_hd__inv_1
X_07936_ _03673_ _03674_ _02350_ VSS VSS VDD VDD _03716_ sky130_fd_sc_hd__a21oi_1
X_07937_ _02367_ _03716_ VSS VSS VDD VDD _02379_ sky130_fd_sc_hd__xnor2_1
X_07938_ _01037_ VSS VSS VDD VDD _02382_ sky130_fd_sc_hd__inv_1
X_07939_ _00590_ _02368_ VSS VSS VDD VDD _03717_ sky130_fd_sc_hd__xor2_1
X_07940_ _02352_ net447 stage3_in_r\[76\] VSS VSS VDD VDD
+ _03718_ sky130_fd_sc_hd__mux2i_1
X_07941_ _03717_ _03718_ VSS VSS VDD VDD _02387_ sky130_fd_sc_hd__xnor2_1
X_07942_ _01032_ VSS VSS VDD VDD _02391_ sky130_fd_sc_hd__inv_1
X_07943_ _02366_ _03616_ VSS VSS VDD VDD _03719_ sky130_fd_sc_hd__nor2_1
X_07944_ _02384_ _03719_ VSS VSS VDD VDD _02395_ sky130_fd_sc_hd__xnor2_1
X_07945_ _00632_ _03717_ net427 VSS VSS VDD VDD _03720_ sky130_fd_sc_hd__a21oi_1
X_07946_ _02352_ _00632_ _03717_ _03720_ VSS VSS VDD VDD _02402_
+ sky130_fd_sc_hd__a31o_2
X_07947_ _01040_ VSS VSS VDD VDD _02407_ sky130_fd_sc_hd__inv_1
X_07948_ _02360_ _02376_ _02392_ VSS VSS VDD VDD _03721_ sky130_fd_sc_hd__nor3_1
X_07949_ _03590_ _02393_ VSS VSS VDD VDD _03722_ sky130_fd_sc_hd__nor2b_1
X_07950_ _02392_ _03722_ VSS VSS VDD VDD _03723_ sky130_fd_sc_hd__nor2_1
X_07951_ _03666_ _03721_ _03723_ VSS VSS VDD VDD _03724_ sky130_fd_sc_hd__a21oi_1
X_07952_ _02409_ _03724_ VSS VSS VDD VDD _02411_ sky130_fd_sc_hd__xnor2_1
X_07953_ _02349_ _03553_ VSS VSS VDD VDD _02440_ sky130_fd_sc_hd__xnor2_1
X_07954_ _03570_ _03625_ VSS VSS VDD VDD _02414_ sky130_fd_sc_hd__xnor2_1
X_07955_ stage2_in_r\[17\] VSS VSS VDD VDD _02528_ sky130_fd_sc_hd__inv_1
X_07956_ stage2_in_r\[145\] VSS VSS VDD VDD _02590_ sky130_fd_sc_hd__inv_1
X_07957_ _01135_ VSS VSS VDD VDD _00012_ sky130_fd_sc_hd__inv_1
X_07958_ _01139_ VSS VSS VDD VDD _00029_ sky130_fd_sc_hd__inv_1
X_07959_ _01175_ VSS VSS VDD VDD _00119_ sky130_fd_sc_hd__inv_1
X_07960_ _01184_ VSS VSS VDD VDD _00126_ sky130_fd_sc_hd__inv_1
X_07961_ _01190_ VSS VSS VDD VDD _00131_ sky130_fd_sc_hd__inv_1
X_07962_ _01200_ VSS VSS VDD VDD _00265_ sky130_fd_sc_hd__inv_1
X_07963_ _01204_ VSS VSS VDD VDD _00137_ sky130_fd_sc_hd__inv_1
X_07964_ _00362_ VSS VSS VDD VDD _00153_ sky130_fd_sc_hd__inv_1
X_07965_ _01207_ VSS VSS VDD VDD _00151_ sky130_fd_sc_hd__inv_1
X_07966_ _01243_ VSS VSS VDD VDD _00249_ sky130_fd_sc_hd__inv_1
X_07967_ _01251_ VSS VSS VDD VDD _01663_ sky130_fd_sc_hd__inv_1
X_07968_ _01254_ VSS VSS VDD VDD _00255_ sky130_fd_sc_hd__inv_1
X_07969_ _01260_ VSS VSS VDD VDD _00260_ sky130_fd_sc_hd__inv_1
X_07970_ _01270_ VSS VSS VDD VDD _00270_ sky130_fd_sc_hd__inv_1
X_07971_ _01282_ VSS VSS VDD VDD _01655_ sky130_fd_sc_hd__inv_1
X_07972_ _01283_ VSS VSS VDD VDD _01659_ sky130_fd_sc_hd__inv_1
X_07973_ _00273_ VSS VSS VDD VDD _00078_ sky130_fd_sc_hd__inv_1
X_07974_ _01286_ VSS VSS VDD VDD _00284_ sky130_fd_sc_hd__inv_1
X_07975_ _00289_ VSS VSS VDD VDD _00211_ sky130_fd_sc_hd__inv_1
X_07976_ _01293_ VSS VSS VDD VDD _00300_ sky130_fd_sc_hd__inv_1
X_07977_ _01302_ VSS VSS VDD VDD _00312_ sky130_fd_sc_hd__inv_1
X_07978_ _01304_ VSS VSS VDD VDD _00315_ sky130_fd_sc_hd__inv_1
X_07979_ _01312_ VSS VSS VDD VDD _00324_ sky130_fd_sc_hd__inv_1
X_07980_ _01314_ VSS VSS VDD VDD _00327_ sky130_fd_sc_hd__inv_1
X_07981_ _01321_ VSS VSS VDD VDD _00334_ sky130_fd_sc_hd__inv_1
X_07982_ _01328_ VSS VSS VDD VDD _00344_ sky130_fd_sc_hd__inv_1
X_07983_ _01340_ VSS VSS VDD VDD _00355_ sky130_fd_sc_hd__inv_1
X_07984_ _01347_ VSS VSS VDD VDD _00365_ sky130_fd_sc_hd__inv_1
X_07985_ _01358_ VSS VSS VDD VDD _00377_ sky130_fd_sc_hd__inv_1
X_07986_ _01371_ VSS VSS VDD VDD _00386_ sky130_fd_sc_hd__inv_1
X_07987_ _01385_ VSS VSS VDD VDD _00400_ sky130_fd_sc_hd__inv_1
X_07988_ _01392_ VSS VSS VDD VDD _00408_ sky130_fd_sc_hd__inv_1
X_07989_ _00425_ VSS VSS VDD VDD _00421_ sky130_fd_sc_hd__inv_1
X_07990_ _01413_ VSS VSS VDD VDD _00427_ sky130_fd_sc_hd__inv_1
X_07991_ _01428_ VSS VSS VDD VDD _00440_ sky130_fd_sc_hd__inv_1
X_07992_ _01433_ VSS VSS VDD VDD _00444_ sky130_fd_sc_hd__inv_1
X_07993_ _00454_ VSS VSS VDD VDD _00450_ sky130_fd_sc_hd__inv_1
X_07994_ _01443_ VSS VSS VDD VDD _00459_ sky130_fd_sc_hd__inv_1
X_07995_ _01451_ VSS VSS VDD VDD _00465_ sky130_fd_sc_hd__inv_1
X_07996_ _01460_ VSS VSS VDD VDD _00472_ sky130_fd_sc_hd__inv_1
X_07997_ _01469_ VSS VSS VDD VDD _00478_ sky130_fd_sc_hd__inv_1
X_07998_ _01477_ VSS VSS VDD VDD _00482_ sky130_fd_sc_hd__inv_1
X_07999_ _01487_ VSS VSS VDD VDD _00488_ sky130_fd_sc_hd__inv_1
X_08000_ _01498_ VSS VSS VDD VDD _00492_ sky130_fd_sc_hd__inv_1
X_08001_ _01508_ VSS VSS VDD VDD _00496_ sky130_fd_sc_hd__inv_1
X_08002_ _01517_ VSS VSS VDD VDD _00500_ sky130_fd_sc_hd__inv_1
X_08003_ _01530_ VSS VSS VDD VDD _00504_ sky130_fd_sc_hd__inv_1
X_08004_ _01817_ VSS VSS VDD VDD _00518_ sky130_fd_sc_hd__inv_1
X_08005_ _01822_ VSS VSS VDD VDD _00515_ sky130_fd_sc_hd__inv_1
X_08006_ _01847_ VSS VSS VDD VDD _00536_ sky130_fd_sc_hd__inv_1
X_08007_ _01884_ VSS VSS VDD VDD _00544_ sky130_fd_sc_hd__inv_1
X_08008_ _01888_ VSS VSS VDD VDD _00552_ sky130_fd_sc_hd__inv_1
X_08009_ _01893_ VSS VSS VDD VDD _00561_ sky130_fd_sc_hd__inv_1
X_08010_ _01898_ VSS VSS VDD VDD _00572_ sky130_fd_sc_hd__inv_1
X_08011_ _01907_ VSS VSS VDD VDD _00582_ sky130_fd_sc_hd__inv_1
X_08012_ _01917_ VSS VSS VDD VDD _00597_ sky130_fd_sc_hd__inv_1
X_08013_ _01928_ VSS VSS VDD VDD _00606_ sky130_fd_sc_hd__inv_1
X_08014_ _02023_ VSS VSS VDD VDD _00661_ sky130_fd_sc_hd__inv_1
X_08015_ _02026_ VSS VSS VDD VDD _00658_ sky130_fd_sc_hd__inv_1
X_08016_ _02048_ VSS VSS VDD VDD _00817_ sky130_fd_sc_hd__inv_1
X_08017_ _00680_ VSS VSS VDD VDD _01840_ sky130_fd_sc_hd__inv_1
X_08018_ _02057_ VSS VSS VDD VDD _00690_ sky130_fd_sc_hd__inv_1
X_08019_ _02061_ VSS VSS VDD VDD _00706_ sky130_fd_sc_hd__inv_1
X_08020_ _02068_ VSS VSS VDD VDD _00758_ sky130_fd_sc_hd__inv_1
X_08021_ _02071_ VSS VSS VDD VDD _00771_ sky130_fd_sc_hd__inv_1
X_08022_ _02087_ VSS VSS VDD VDD _00796_ sky130_fd_sc_hd__inv_1
X_08023_ _02096_ VSS VSS VDD VDD _00807_ sky130_fd_sc_hd__inv_1
X_08024_ _02103_ VSS VSS VDD VDD _00812_ sky130_fd_sc_hd__inv_1
X_08025_ _02114_ VSS VSS VDD VDD _00822_ sky130_fd_sc_hd__inv_1
X_08026_ _02158_ VSS VSS VDD VDD _02159_ sky130_fd_sc_hd__inv_1
X_08027_ _02162_ VSS VSS VDD VDD _02163_ sky130_fd_sc_hd__inv_1
X_08028_ _02173_ VSS VSS VDD VDD _00828_ sky130_fd_sc_hd__inv_1
X_08029_ _00760_ VSS VSS VDD VDD _01829_ sky130_fd_sc_hd__inv_1
X_08030_ _02179_ VSS VSS VDD VDD _00842_ sky130_fd_sc_hd__inv_1
X_08031_ _02188_ VSS VSS VDD VDD _00850_ sky130_fd_sc_hd__inv_1
X_08032_ _00856_ VSS VSS VDD VDD _01823_ sky130_fd_sc_hd__inv_1
X_08033_ _02195_ VSS VSS VDD VDD _00862_ sky130_fd_sc_hd__inv_1
X_08034_ _02197_ VSS VSS VDD VDD _00865_ sky130_fd_sc_hd__inv_1
X_08035_ _02206_ VSS VSS VDD VDD _00873_ sky130_fd_sc_hd__inv_1
X_08036_ _00881_ VSS VSS VDD VDD _00523_ sky130_fd_sc_hd__inv_1
X_08037_ _02213_ VSS VSS VDD VDD _00884_ sky130_fd_sc_hd__inv_1
X_08038_ _02223_ VSS VSS VDD VDD _00895_ sky130_fd_sc_hd__inv_1
X_08039_ _00693_ VSS VSS VDD VDD _00520_ sky130_fd_sc_hd__inv_1
X_08040_ _02234_ VSS VSS VDD VDD _00905_ sky130_fd_sc_hd__inv_1
X_08041_ _02251_ VSS VSS VDD VDD _00915_ sky130_fd_sc_hd__inv_1
X_08042_ _02256_ VSS VSS VDD VDD _00927_ sky130_fd_sc_hd__inv_1
X_08043_ _02273_ VSS VSS VDD VDD _00940_ sky130_fd_sc_hd__inv_1
X_08044_ _02280_ VSS VSS VDD VDD _00953_ sky130_fd_sc_hd__inv_1
X_08045_ _02295_ VSS VSS VDD VDD _00959_ sky130_fd_sc_hd__inv_1
X_08046_ _00976_ VSS VSS VDD VDD _00972_ sky130_fd_sc_hd__inv_1
X_08047_ _02323_ VSS VSS VDD VDD _00991_ sky130_fd_sc_hd__inv_1
X_08048_ _02341_ VSS VSS VDD VDD _01007_ sky130_fd_sc_hd__inv_1
X_08049_ _02357_ VSS VSS VDD VDD _01023_ sky130_fd_sc_hd__inv_1
X_08050_ _02373_ VSS VSS VDD VDD _01031_ sky130_fd_sc_hd__inv_1
X_08051_ _02389_ VSS VSS VDD VDD _01039_ sky130_fd_sc_hd__inv_1
X_08052_ _02405_ VSS VSS VDD VDD _01042_ sky130_fd_sc_hd__inv_1
X_08053_ _01131_ VSS VSS VDD VDD _00016_ sky130_fd_sc_hd__inv_1
X_08054_ _00024_ VSS VSS VDD VDD _00020_ sky130_fd_sc_hd__inv_1
X_08055_ _01136_ VSS VSS VDD VDD _00036_ sky130_fd_sc_hd__inv_1
X_08056_ _00161_ VSS VSS VDD VDD _00156_ sky130_fd_sc_hd__inv_1
X_08057_ _01208_ VSS VSS VDD VDD _00172_ sky130_fd_sc_hd__inv_1
X_08058_ _01211_ VSS VSS VDD VDD _00166_ sky130_fd_sc_hd__inv_1
X_08059_ _01244_ VSS VSS VDD VDD _01667_ sky130_fd_sc_hd__inv_1
X_08060_ _01415_ VSS VSS VDD VDD _00432_ sky130_fd_sc_hd__inv_1
X_08061_ _01824_ VSS VSS VDD VDD _02169_ sky130_fd_sc_hd__inv_1
X_08062_ _01827_ VSS VSS VDD VDD _00528_ sky130_fd_sc_hd__inv_1
X_08063_ _01844_ VSS VSS VDD VDD _00692_ sky130_fd_sc_hd__inv_1
X_08064_ _00701_ VSS VSS VDD VDD _00697_ sky130_fd_sc_hd__inv_1
X_08065_ _01941_ VSS VSS VDD VDD _00616_ sky130_fd_sc_hd__inv_1
X_08066_ _02033_ VSS VSS VDD VDD _00673_ sky130_fd_sc_hd__inv_1
X_08067_ _02054_ VSS VSS VDD VDD _00682_ sky130_fd_sc_hd__inv_1
X_08068_ _02058_ VSS VSS VDD VDD _00713_ sky130_fd_sc_hd__inv_1
X_08069_ _02093_ VSS VSS VDD VDD _02166_ sky130_fd_sc_hd__inv_1
X_08070_ _02317_ VSS VSS VDD VDD _00980_ sky130_fd_sc_hd__inv_1
X_08071_ _01130_ VSS VSS VDD VDD _00280_ sky130_fd_sc_hd__inv_1
X_08072_ _01140_ VSS VSS VDD VDD _00045_ sky130_fd_sc_hd__inv_1
X_08073_ _01160_ VSS VSS VDD VDD _00655_ sky130_fd_sc_hd__inv_1
X_08074_ _00219_ VSS VSS VDD VDD _00138_ sky130_fd_sc_hd__inv_1
X_08075_ _01298_ VSS VSS VDD VDD _02333_ sky130_fd_sc_hd__inv_1
X_08076_ _01360_ VSS VSS VDD VDD _00399_ sky130_fd_sc_hd__inv_1
X_08077_ _01394_ VSS VSS VDD VDD _00431_ sky130_fd_sc_hd__inv_1
X_08078_ _01027_ VSS VSS VDD VDD _01010_ sky130_fd_sc_hd__inv_1
X_08079_ _01818_ VSS VSS VDD VDD _00513_ sky130_fd_sc_hd__inv_1
X_08080_ _00524_ VSS VSS VDD VDD _00802_ sky130_fd_sc_hd__inv_1
X_08081_ _01839_ VSS VSS VDD VDD _00684_ sky130_fd_sc_hd__inv_1
X_08082_ _01936_ VSS VSS VDD VDD _01945_ sky130_fd_sc_hd__inv_1
X_08083_ _01939_ VSS VSS VDD VDD _00625_ sky130_fd_sc_hd__inv_1
X_08084_ _01946_ VSS VSS VDD VDD _00636_ sky130_fd_sc_hd__inv_1
X_08085_ _02053_ VSS VSS VDD VDD _00839_ sky130_fd_sc_hd__inv_1
X_08086_ _02062_ VSS VSS VDD VDD _00721_ sky130_fd_sc_hd__inv_1
X_08087_ _02258_ VSS VSS VDD VDD _00952_ sky130_fd_sc_hd__inv_1
X_08088_ _02315_ VSS VSS VDD VDD _00996_ sky130_fd_sc_hd__inv_1
X_08089_ _02334_ VSS VSS VDD VDD _01013_ sky130_fd_sc_hd__inv_1
X_08090_ _00643_ VSS VSS VDD VDD _00633_ sky130_fd_sc_hd__inv_1
X_08091_ _02861_ VSS VSS VDD VDD _03725_ sky130_fd_sc_hd__inv_1
X_08092_ _02857_ VSS VSS VDD VDD _03726_ sky130_fd_sc_hd__inv_1
X_08093_ _02853_ VSS VSS VDD VDD _03727_ sky130_fd_sc_hd__inv_1
X_08094_ _02849_ VSS VSS VDD VDD _03728_ sky130_fd_sc_hd__inv_1
X_08095_ _02845_ VSS VSS VDD VDD _03729_ sky130_fd_sc_hd__inv_1
X_08096_ _02841_ VSS VSS VDD VDD _03730_ sky130_fd_sc_hd__inv_1
X_08097_ _02837_ VSS VSS VDD VDD _03731_ sky130_fd_sc_hd__inv_1
X_08098_ stage1_in_r\[240\] stage1_in_r\[208\] VSS VSS VDD
+ VDD _03732_ sky130_fd_sc_hd__nand2b_1
X_08099_ _02829_ _03732_ _02828_ VSS VSS VDD VDD _03733_ sky130_fd_sc_hd__a21o_1
X_08100_ _02833_ _03733_ _02832_ VSS VSS VDD VDD _03734_ sky130_fd_sc_hd__a21oi_1
X_08101_ _03731_ _03734_ _02836_ VSS VSS VDD VDD _03735_ sky130_fd_sc_hd__o21ba_2
X_08102_ _03730_ _03735_ _02840_ VSS VSS VDD VDD _03736_ sky130_fd_sc_hd__o21ba_2
X_08103_ _03729_ _03736_ _02844_ VSS VSS VDD VDD _03737_ sky130_fd_sc_hd__o21ba_2
X_08104_ _03728_ _03737_ _02848_ VSS VSS VDD VDD _03738_ sky130_fd_sc_hd__o21ba_2
X_08105_ _03727_ _03738_ _02852_ VSS VSS VDD VDD _03739_ sky130_fd_sc_hd__o21ba_2
X_08106_ _03726_ _03739_ _02856_ VSS VSS VDD VDD _03740_ sky130_fd_sc_hd__o21ba_2
X_08107_ _03725_ _03740_ _02860_ VSS VSS VDD VDD _03741_ sky130_fd_sc_hd__o21ba_2
X_08108_ _02865_ _03741_ VSS VSS VDD VDD stage1_out\[217\]
+ sky130_fd_sc_hd__xnor2_1
X_08109_ _02865_ VSS VSS VDD VDD _03742_ sky130_fd_sc_hd__inv_1
X_08110_ _03742_ _03741_ _02864_ VSS VSS VDD VDD _03743_ sky130_fd_sc_hd__o21ba_2
X_08111_ _02869_ _03743_ VSS VSS VDD VDD stage1_out\[218\]
+ sky130_fd_sc_hd__xnor2_1
X_08112_ _02869_ VSS VSS VDD VDD _03744_ sky130_fd_sc_hd__inv_1
X_08113_ _03744_ _03743_ _02868_ VSS VSS VDD VDD _03745_ sky130_fd_sc_hd__o21ba_2
X_08114_ _02873_ _03745_ VSS VSS VDD VDD stage1_out\[219\]
+ sky130_fd_sc_hd__xnor2_1
X_08115_ _02877_ VSS VSS VDD VDD _03746_ sky130_fd_sc_hd__inv_1
X_08116_ _02873_ VSS VSS VDD VDD _03747_ sky130_fd_sc_hd__inv_1
X_08117_ _03747_ _03745_ _02872_ VSS VSS VDD VDD _03748_ sky130_fd_sc_hd__o21bai_1
X_08118_ _03746_ _03748_ VSS VSS VDD VDD stage1_out\[220\]
+ sky130_fd_sc_hd__xnor2_1
Xinput131 in_flat[73] VSS VSS VDD VDD net130 sky130_fd_sc_hd__clkdlybuf4s50_1
X_08120_ _02877_ _03748_ _02876_ VSS VSS VDD VDD _03750_ sky130_fd_sc_hd__a21o_1
X_08121_ _02881_ _03750_ VSS VSS VDD VDD stage1_out\[221\]
+ sky130_fd_sc_hd__xor2_1
Xinput130 in_flat[72] VSS VSS VDD VDD net129 sky130_fd_sc_hd__clkdlybuf4s50_1
X_08123_ _02885_ VSS VSS VDD VDD _03752_ sky130_fd_sc_hd__inv_1
X_08124_ _02877_ _03748_ _02880_ _02876_ _03752_ VSS VSS VDD
+ VDD _03753_ sky130_fd_sc_hd__a2111o_1
X_08125_ _02885_ _02881_ VSS VSS VDD VDD _03754_ sky130_fd_sc_hd__nor2b_1
X_08126_ _02877_ _03748_ _03754_ VSS VSS VDD VDD _03755_ sky130_fd_sc_hd__nand3_1
X_08127_ _02881_ _03752_ _02880_ VSS VSS VDD VDD _03756_ sky130_fd_sc_hd__nor3_1
X_08128_ _03752_ _02880_ _03754_ _02876_ _03756_ VSS VSS VDD
+ VDD _03757_ sky130_fd_sc_hd__a221oi_1
X_08129_ _03753_ _03755_ _03757_ VSS VSS VDD VDD stage1_out\[222\]
+ sky130_fd_sc_hd__nand3_1
X_08130_ _02881_ _03752_ _02880_ _02884_ VSS VSS VDD VDD _03758_
+ sky130_fd_sc_hd__nor4_1
X_08131_ _03752_ _02884_ _03758_ VSS VSS VDD VDD _03759_ sky130_fd_sc_hd__a21oi_1
X_08132_ _03752_ _02880_ _02884_ _03750_ _03759_ VSS VSS VDD
+ VDD stage1_out\[223\] sky130_fd_sc_hd__o41ai_1
X_08133_ _02833_ VSS VSS VDD VDD _03760_ sky130_fd_sc_hd__inv_1
X_08134_ _03760_ _03733_ VSS VSS VDD VDD stage1_out\[209\]
+ sky130_fd_sc_hd__xnor2_1
X_08135_ _02837_ _03734_ VSS VSS VDD VDD stage1_out\[210\]
+ sky130_fd_sc_hd__xnor2_1
X_08136_ _02841_ _03735_ VSS VSS VDD VDD stage1_out\[211\]
+ sky130_fd_sc_hd__xnor2_1
X_08137_ _02845_ _03736_ VSS VSS VDD VDD stage1_out\[212\]
+ sky130_fd_sc_hd__xnor2_1
X_08138_ _02849_ _03737_ VSS VSS VDD VDD stage1_out\[213\]
+ sky130_fd_sc_hd__xnor2_1
X_08139_ _02853_ _03738_ VSS VSS VDD VDD stage1_out\[214\]
+ sky130_fd_sc_hd__xnor2_1
X_08140_ _02857_ _03739_ VSS VSS VDD VDD stage1_out\[215\]
+ sky130_fd_sc_hd__xnor2_1
X_08141_ _02861_ _03740_ VSS VSS VDD VDD stage1_out\[216\]
+ sky130_fd_sc_hd__xnor2_1
X_08142_ _02833_ _01049_ _02834_ VSS VSS VDD VDD _03761_ sky130_fd_sc_hd__o21bai_1
X_08143_ _03731_ _03761_ _02838_ VSS VSS VDD VDD _03762_ sky130_fd_sc_hd__a21o_1
X_08144_ _03730_ _03762_ _02842_ VSS VSS VDD VDD _03763_ sky130_fd_sc_hd__a21oi_1
X_08145_ _02845_ _03763_ _02846_ VSS VSS VDD VDD _03764_ sky130_fd_sc_hd__o21bai_1
X_08146_ _03728_ _03764_ _02850_ VSS VSS VDD VDD _03765_ sky130_fd_sc_hd__a21oi_1
X_08147_ _02853_ _03765_ _02854_ VSS VSS VDD VDD _03766_ sky130_fd_sc_hd__o21bai_1
X_08148_ _03726_ _03766_ _02858_ VSS VSS VDD VDD _03767_ sky130_fd_sc_hd__a21oi_1
X_08149_ _02861_ _03767_ _02862_ VSS VSS VDD VDD _03768_ sky130_fd_sc_hd__o21bai_1
X_08150_ _02865_ _03768_ VSS VSS VDD VDD stage1_out\[249\]
+ sky130_fd_sc_hd__xnor2_1
X_08151_ _02829_ _01048_ _02830_ VSS VSS VDD VDD _03769_ sky130_fd_sc_hd__o21bai_1
X_08152_ _03760_ _03769_ _02834_ VSS VSS VDD VDD _03770_ sky130_fd_sc_hd__a21oi_1
X_08153_ _02837_ _03770_ _02838_ VSS VSS VDD VDD _03771_ sky130_fd_sc_hd__o21bai_1
X_08154_ _03730_ _03771_ _02842_ VSS VSS VDD VDD _03772_ sky130_fd_sc_hd__a21oi_1
X_08155_ _02845_ _03772_ _02846_ VSS VSS VDD VDD _03773_ sky130_fd_sc_hd__o21bai_1
X_08156_ _03728_ _03773_ _02850_ VSS VSS VDD VDD _03774_ sky130_fd_sc_hd__a21oi_1
X_08157_ _02853_ _03774_ _02854_ VSS VSS VDD VDD _03775_ sky130_fd_sc_hd__o21bai_1
X_08158_ _03726_ _03775_ _02858_ VSS VSS VDD VDD _03776_ sky130_fd_sc_hd__a21oi_1
X_08159_ _02861_ _03776_ _02862_ VSS VSS VDD VDD _03777_ sky130_fd_sc_hd__o21bai_1
X_08160_ _03742_ _03777_ _02866_ VSS VSS VDD VDD _03778_ sky130_fd_sc_hd__a21oi_1
X_08161_ _03744_ _03778_ VSS VSS VDD VDD stage1_out\[250\]
+ sky130_fd_sc_hd__xnor2_1
X_08162_ _03742_ _03768_ _02866_ VSS VSS VDD VDD _03779_ sky130_fd_sc_hd__a21oi_1
X_08163_ _02869_ _03779_ _02870_ VSS VSS VDD VDD _03780_ sky130_fd_sc_hd__o21bai_1
X_08164_ _02873_ _03780_ VSS VSS VDD VDD stage1_out\[251\]
+ sky130_fd_sc_hd__xnor2_1
X_08165_ _02869_ _03778_ _02870_ VSS VSS VDD VDD _03781_ sky130_fd_sc_hd__o21bai_1
X_08166_ _03747_ _03781_ _02874_ VSS VSS VDD VDD _03782_ sky130_fd_sc_hd__a21oi_1
X_08167_ _03746_ _03782_ VSS VSS VDD VDD stage1_out\[252\]
+ sky130_fd_sc_hd__xnor2_1
X_08168_ _03747_ _03780_ _02874_ VSS VSS VDD VDD _03783_ sky130_fd_sc_hd__a21oi_1
X_08169_ _02877_ _03783_ VSS VSS VDD VDD _03784_ sky130_fd_sc_hd__nor2_1
X_08170_ _02878_ _03784_ VSS VSS VDD VDD _03785_ sky130_fd_sc_hd__nor2_1
X_08171_ _02881_ _03785_ VSS VSS VDD VDD stage1_out\[253\]
+ sky130_fd_sc_hd__xor2_1
X_08172_ _02878_ _02882_ VSS VSS VDD VDD _03786_ sky130_fd_sc_hd__nor2_1
X_08173_ _02877_ _03782_ _03786_ _02885_ VSS VSS VDD VDD _03787_
+ sky130_fd_sc_hd__o211a_1
X_08174_ _02877_ _02881_ _02885_ _03782_ VSS VSS VDD VDD _03788_
+ sky130_fd_sc_hd__nor4_1
X_08175_ _02882_ VSS VSS VDD VDD _03789_ sky130_fd_sc_hd__inv_1
X_08176_ _02881_ _02885_ _02878_ VSS VSS VDD VDD _03790_ sky130_fd_sc_hd__nor3b_1
X_08177_ _02881_ _03789_ _02885_ _03790_ VSS VSS VDD VDD _03791_
+ sky130_fd_sc_hd__a31oi_1
X_08178_ _03789_ _02885_ _03791_ VSS VSS VDD VDD _03792_ sky130_fd_sc_hd__o21ai_0
X_08179_ _03787_ _03788_ _03792_ VSS VSS VDD VDD stage1_out\[254\]
+ sky130_fd_sc_hd__nor3_1
X_08180_ _02882_ _02885_ _02886_ VSS VSS VDD VDD _03793_ sky130_fd_sc_hd__nor3_1
X_08181_ _02881_ _03785_ _03793_ VSS VSS VDD VDD _03794_ sky130_fd_sc_hd__o21ai_0
X_08182_ _02885_ _02886_ VSS VSS VDD VDD _03795_ sky130_fd_sc_hd__nand2_1
X_08183_ _03794_ _03795_ VSS VSS VDD VDD stage1_out\[255\]
+ sky130_fd_sc_hd__nand2_1
X_08184_ _02833_ _01049_ VSS VSS VDD VDD stage1_out\[241\]
+ sky130_fd_sc_hd__xor2_1
X_08185_ _03731_ _03770_ VSS VSS VDD VDD stage1_out\[242\]
+ sky130_fd_sc_hd__xnor2_1
X_08186_ _02841_ _03762_ VSS VSS VDD VDD stage1_out\[243\]
+ sky130_fd_sc_hd__xnor2_1
X_08187_ _03729_ _03772_ VSS VSS VDD VDD stage1_out\[244\]
+ sky130_fd_sc_hd__xnor2_1
X_08188_ _02849_ _03764_ VSS VSS VDD VDD stage1_out\[245\]
+ sky130_fd_sc_hd__xnor2_1
X_08189_ _03727_ _03774_ VSS VSS VDD VDD stage1_out\[246\]
+ sky130_fd_sc_hd__xnor2_1
X_08190_ _02857_ _03766_ VSS VSS VDD VDD stage1_out\[247\]
+ sky130_fd_sc_hd__xnor2_1
X_08191_ _03725_ _03776_ VSS VSS VDD VDD stage1_out\[248\]
+ sky130_fd_sc_hd__xnor2_1
X_08192_ _02801_ VSS VSS VDD VDD _03796_ sky130_fd_sc_hd__inv_1
X_08193_ _02793_ VSS VSS VDD VDD _03797_ sky130_fd_sc_hd__inv_1
X_08194_ _02785_ VSS VSS VDD VDD _03798_ sky130_fd_sc_hd__inv_1
X_08195_ _02777_ VSS VSS VDD VDD _03799_ sky130_fd_sc_hd__inv_1
X_08196_ _01053_ _02774_ VSS VSS VDD VDD _03800_ sky130_fd_sc_hd__nor2b_1
X_08197_ _02773_ _03800_ _02778_ VSS VSS VDD VDD _03801_ sky130_fd_sc_hd__o21ai_0
X_08198_ _02782_ VSS VSS VDD VDD _03802_ sky130_fd_sc_hd__inv_1
X_08199_ _03799_ _03801_ _03802_ VSS VSS VDD VDD _03803_ sky130_fd_sc_hd__a21oi_1
X_08200_ _02781_ _03803_ _02786_ VSS VSS VDD VDD _03804_ sky130_fd_sc_hd__o21ai_0
X_08201_ _02790_ VSS VSS VDD VDD _03805_ sky130_fd_sc_hd__inv_1
X_08202_ _03798_ _03804_ _03805_ VSS VSS VDD VDD _03806_ sky130_fd_sc_hd__a21oi_1
X_08203_ _02789_ _03806_ _02794_ VSS VSS VDD VDD _03807_ sky130_fd_sc_hd__o21ai_0
X_08204_ _02798_ VSS VSS VDD VDD _03808_ sky130_fd_sc_hd__inv_1
X_08205_ _03797_ _03807_ _03808_ VSS VSS VDD VDD _03809_ sky130_fd_sc_hd__a21oi_1
X_08206_ _02797_ _03809_ _02802_ VSS VSS VDD VDD _03810_ sky130_fd_sc_hd__o21ai_0
X_08207_ _02806_ VSS VSS VDD VDD _03811_ sky130_fd_sc_hd__inv_1
X_08208_ _03796_ _03810_ _03811_ VSS VSS VDD VDD _03812_ sky130_fd_sc_hd__a21oi_1
X_08209_ _03811_ _03796_ _03810_ VSS VSS VDD VDD _03813_ sky130_fd_sc_hd__and3_1
X_08210_ _03812_ _03813_ VSS VSS VDD VDD stage1_out\[153\]
+ sky130_fd_sc_hd__nor2_1
X_08211_ _02802_ VSS VSS VDD VDD _03814_ sky130_fd_sc_hd__inv_1
X_08212_ _02794_ VSS VSS VDD VDD _03815_ sky130_fd_sc_hd__inv_1
X_08213_ _02786_ VSS VSS VDD VDD _03816_ sky130_fd_sc_hd__inv_1
X_08214_ _02778_ VSS VSS VDD VDD _03817_ sky130_fd_sc_hd__inv_1
X_08215_ _02770_ VSS VSS VDD VDD _03818_ sky130_fd_sc_hd__inv_1
X_08216_ _03818_ _01052_ _02769_ VSS VSS VDD VDD _03819_ sky130_fd_sc_hd__o21bai_1
X_08217_ _02774_ _03819_ _02773_ VSS VSS VDD VDD _03820_ sky130_fd_sc_hd__a21oi_1
X_08218_ _03817_ _03820_ _03799_ VSS VSS VDD VDD _03821_ sky130_fd_sc_hd__o21ai_0
X_08219_ _02782_ _03821_ _02781_ VSS VSS VDD VDD _03822_ sky130_fd_sc_hd__a21oi_1
X_08220_ _03816_ _03822_ _03798_ VSS VSS VDD VDD _03823_ sky130_fd_sc_hd__o21ai_0
X_08221_ _02790_ _03823_ _02789_ VSS VSS VDD VDD _03824_ sky130_fd_sc_hd__a21oi_1
X_08222_ _03815_ _03824_ _03797_ VSS VSS VDD VDD _03825_ sky130_fd_sc_hd__o21ai_0
X_08223_ _02798_ _03825_ _02797_ VSS VSS VDD VDD _03826_ sky130_fd_sc_hd__a21oi_1
X_08224_ _03814_ _03826_ _03796_ VSS VSS VDD VDD _03827_ sky130_fd_sc_hd__o21ai_0
X_08225_ _02806_ _03827_ _02805_ VSS VSS VDD VDD _03828_ sky130_fd_sc_hd__a21oi_1
X_08226_ _02810_ _03828_ VSS VSS VDD VDD stage1_out\[154\]
+ sky130_fd_sc_hd__xnor2_1
X_08227_ _02809_ VSS VSS VDD VDD _03829_ sky130_fd_sc_hd__inv_1
X_08228_ _02805_ _03812_ _02810_ VSS VSS VDD VDD _03830_ sky130_fd_sc_hd__o21ai_0
X_08229_ _02814_ VSS VSS VDD VDD _03831_ sky130_fd_sc_hd__inv_1
X_08230_ _03829_ _03830_ _03831_ VSS VSS VDD VDD _03832_ sky130_fd_sc_hd__a21oi_1
X_08231_ _03831_ _03829_ _03830_ VSS VSS VDD VDD _03833_ sky130_fd_sc_hd__and3_1
X_08232_ _03832_ _03833_ VSS VSS VDD VDD stage1_out\[155\]
+ sky130_fd_sc_hd__nor2_1
Xinput129 in_flat[71] VSS VSS VDD VDD net128 sky130_fd_sc_hd__clkdlybuf4s50_1
X_08234_ _02810_ VSS VSS VDD VDD _03835_ sky130_fd_sc_hd__inv_1
X_08235_ _03835_ _03828_ _03829_ VSS VSS VDD VDD _03836_ sky130_fd_sc_hd__o21ai_0
X_08236_ _02814_ _03836_ _02813_ VSS VSS VDD VDD _03837_ sky130_fd_sc_hd__a21oi_1
X_08237_ _02818_ _03837_ VSS VSS VDD VDD stage1_out\[156\]
+ sky130_fd_sc_hd__xnor2_1
Xinput128 in_flat[70] VSS VSS VDD VDD net127 sky130_fd_sc_hd__clkdlybuf4s50_1
X_08239_ _02813_ _03832_ _02818_ VSS VSS VDD VDD _03839_ sky130_fd_sc_hd__o21a_1
X_08240_ _02817_ _03839_ VSS VSS VDD VDD _03840_ sky130_fd_sc_hd__nor2_1
X_08241_ _02822_ _03840_ VSS VSS VDD VDD stage1_out\[157\]
+ sky130_fd_sc_hd__xnor2_1
X_08242_ _02818_ VSS VSS VDD VDD _03841_ sky130_fd_sc_hd__inv_1
Xinput127 in_flat[6] VSS VSS VDD VDD net126 sky130_fd_sc_hd__clkdlybuf4s50_1
X_08244_ _02826_ VSS VSS VDD VDD _03843_ sky130_fd_sc_hd__inv_1
X_08245_ _03843_ _02817_ _02821_ VSS VSS VDD VDD _03844_ sky130_fd_sc_hd__nor3_1
X_08246_ _03841_ _03837_ _03844_ VSS VSS VDD VDD _03845_ sky130_fd_sc_hd__o21ai_0
X_08247_ _02826_ _02822_ VSS VSS VDD VDD _03846_ sky130_fd_sc_hd__nor2b_1
X_08248_ _03837_ _03846_ _02818_ VSS VSS VDD VDD _03847_ sky130_fd_sc_hd__nand3b_1
X_08249_ _02822_ _03843_ _02821_ VSS VSS VDD VDD _03848_ sky130_fd_sc_hd__nor3_1
X_08250_ _03843_ _02821_ _03846_ _02817_ _03848_ VSS VSS VDD
+ VDD _03849_ sky130_fd_sc_hd__a221oi_1
X_08251_ _03845_ _03847_ _03849_ VSS VSS VDD VDD stage1_out\[158\]
+ sky130_fd_sc_hd__nand3_1
X_08252_ _03840_ _02822_ VSS VSS VDD VDD _03850_ sky130_fd_sc_hd__nand2b_1
X_08253_ _03843_ _02821_ _02825_ VSS VSS VDD VDD _03851_ sky130_fd_sc_hd__nor3_1
X_08254_ _03843_ _02825_ _03850_ _03851_ VSS VSS VDD VDD stage1_out\[159\]
+ sky130_fd_sc_hd__a22o_1
X_08255_ _01053_ _02774_ VSS VSS VDD VDD stage1_out\[145\]
+ sky130_fd_sc_hd__xnor2_1
X_08256_ _02778_ _03820_ VSS VSS VDD VDD stage1_out\[146\]
+ sky130_fd_sc_hd__xnor2_1
X_08257_ _03802_ _03799_ _03801_ VSS VSS VDD VDD _03852_ sky130_fd_sc_hd__and3_1
X_08258_ _03803_ _03852_ VSS VSS VDD VDD stage1_out\[147\]
+ sky130_fd_sc_hd__nor2_1
X_08259_ _02786_ _03822_ VSS VSS VDD VDD stage1_out\[148\]
+ sky130_fd_sc_hd__xnor2_1
X_08260_ _03805_ _03798_ _03804_ VSS VSS VDD VDD _03853_ sky130_fd_sc_hd__and3_1
X_08261_ _03806_ _03853_ VSS VSS VDD VDD stage1_out\[149\]
+ sky130_fd_sc_hd__nor2_1
X_08262_ _02794_ _03824_ VSS VSS VDD VDD stage1_out\[150\]
+ sky130_fd_sc_hd__xnor2_1
X_08263_ _03808_ _03797_ _03807_ VSS VSS VDD VDD _03854_ sky130_fd_sc_hd__and3_1
X_08264_ _03809_ _03854_ VSS VSS VDD VDD stage1_out\[151\]
+ sky130_fd_sc_hd__nor2_1
X_08265_ _02802_ _03826_ VSS VSS VDD VDD stage1_out\[152\]
+ sky130_fd_sc_hd__xnor2_1
X_08266_ _02774_ _01057_ _02775_ VSS VSS VDD VDD _03855_ sky130_fd_sc_hd__o21bai_1
X_08267_ _03817_ _03855_ _02779_ VSS VSS VDD VDD _03856_ sky130_fd_sc_hd__a21o_1
X_08268_ _03802_ _03856_ _02783_ VSS VSS VDD VDD _03857_ sky130_fd_sc_hd__a21oi_1
X_08269_ _02786_ _03857_ _02787_ VSS VSS VDD VDD _03858_ sky130_fd_sc_hd__o21bai_1
X_08270_ _03805_ _03858_ _02791_ VSS VSS VDD VDD _03859_ sky130_fd_sc_hd__a21oi_1
X_08271_ _02794_ _03859_ _02795_ VSS VSS VDD VDD _03860_ sky130_fd_sc_hd__o21bai_1
X_08272_ _03808_ _03860_ _02799_ VSS VSS VDD VDD _03861_ sky130_fd_sc_hd__a21oi_1
X_08273_ _02802_ _03861_ _02803_ VSS VSS VDD VDD _03862_ sky130_fd_sc_hd__o21bai_1
X_08274_ _02806_ _03862_ VSS VSS VDD VDD stage1_out\[185\]
+ sky130_fd_sc_hd__xnor2_1
X_08275_ _02774_ VSS VSS VDD VDD _03863_ sky130_fd_sc_hd__inv_1
X_08276_ _02770_ _01056_ _02771_ VSS VSS VDD VDD _03864_ sky130_fd_sc_hd__o21bai_1
X_08277_ _03863_ _03864_ _02775_ VSS VSS VDD VDD _03865_ sky130_fd_sc_hd__a21oi_1
X_08278_ _02778_ _03865_ _02779_ VSS VSS VDD VDD _03866_ sky130_fd_sc_hd__o21bai_1
X_08279_ _03802_ _03866_ _02783_ VSS VSS VDD VDD _03867_ sky130_fd_sc_hd__a21oi_1
X_08280_ _02786_ _03867_ _02787_ VSS VSS VDD VDD _03868_ sky130_fd_sc_hd__o21bai_1
X_08281_ _03805_ _03868_ _02791_ VSS VSS VDD VDD _03869_ sky130_fd_sc_hd__a21oi_1
X_08282_ _02794_ _03869_ _02795_ VSS VSS VDD VDD _03870_ sky130_fd_sc_hd__o21bai_1
X_08283_ _03808_ _03870_ _02799_ VSS VSS VDD VDD _03871_ sky130_fd_sc_hd__a21oi_1
X_08284_ _02802_ _03871_ _02803_ VSS VSS VDD VDD _03872_ sky130_fd_sc_hd__o21bai_1
X_08285_ _03811_ _03872_ _02807_ VSS VSS VDD VDD _03873_ sky130_fd_sc_hd__a21oi_1
X_08286_ _03835_ _03873_ VSS VSS VDD VDD stage1_out\[186\]
+ sky130_fd_sc_hd__xnor2_1
X_08287_ _03811_ _03862_ _02807_ VSS VSS VDD VDD _03874_ sky130_fd_sc_hd__a21oi_1
X_08288_ _02810_ _03874_ _02811_ VSS VSS VDD VDD _03875_ sky130_fd_sc_hd__o21bai_1
X_08289_ _02814_ _03875_ VSS VSS VDD VDD stage1_out\[187\]
+ sky130_fd_sc_hd__xnor2_1
X_08290_ _02810_ _03873_ _02811_ VSS VSS VDD VDD _03876_ sky130_fd_sc_hd__o21bai_1
X_08291_ _03831_ _03876_ _02815_ VSS VSS VDD VDD _03877_ sky130_fd_sc_hd__a21oi_1
X_08292_ _03841_ _03877_ VSS VSS VDD VDD stage1_out\[188\]
+ sky130_fd_sc_hd__xnor2_1
X_08293_ _03831_ _03875_ _02815_ VSS VSS VDD VDD _03878_ sky130_fd_sc_hd__a21oi_1
X_08294_ _02818_ _03878_ VSS VSS VDD VDD _03879_ sky130_fd_sc_hd__nor2_1
X_08295_ _02819_ _03879_ VSS VSS VDD VDD _03880_ sky130_fd_sc_hd__nor2_1
X_08296_ _02822_ _03880_ VSS VSS VDD VDD stage1_out\[189\]
+ sky130_fd_sc_hd__xor2_1
X_08297_ _02819_ _02823_ VSS VSS VDD VDD _03881_ sky130_fd_sc_hd__nor2_1
X_08298_ _02818_ _03877_ _03881_ _02826_ VSS VSS VDD VDD _03882_
+ sky130_fd_sc_hd__o211a_1
X_08299_ _02818_ _02822_ _02826_ _03877_ VSS VSS VDD VDD _03883_
+ sky130_fd_sc_hd__nor4_1
X_08300_ _02823_ VSS VSS VDD VDD _03884_ sky130_fd_sc_hd__inv_1
X_08301_ _02822_ _02826_ _02819_ VSS VSS VDD VDD _03885_ sky130_fd_sc_hd__nor3b_1
X_08302_ _02822_ _03884_ _02826_ _03885_ VSS VSS VDD VDD _03886_
+ sky130_fd_sc_hd__a31oi_1
X_08303_ _03884_ _02826_ _03886_ VSS VSS VDD VDD _03887_ sky130_fd_sc_hd__o21ai_0
X_08304_ _03882_ _03883_ _03887_ VSS VSS VDD VDD stage1_out\[190\]
+ sky130_fd_sc_hd__nor3_1
X_08305_ _02823_ _02826_ _02827_ VSS VSS VDD VDD _03888_ sky130_fd_sc_hd__nor3_1
X_08306_ _02822_ _03880_ _03888_ VSS VSS VDD VDD _03889_ sky130_fd_sc_hd__o21ai_0
X_08307_ _02826_ _02827_ VSS VSS VDD VDD _03890_ sky130_fd_sc_hd__nand2_1
X_08308_ _03889_ _03890_ VSS VSS VDD VDD stage1_out\[191\]
+ sky130_fd_sc_hd__nand2_1
X_08309_ _02774_ _01057_ VSS VSS VDD VDD stage1_out\[177\]
+ sky130_fd_sc_hd__xor2_1
X_08310_ _03817_ _03865_ VSS VSS VDD VDD stage1_out\[178\]
+ sky130_fd_sc_hd__xnor2_1
X_08311_ _02782_ _03856_ VSS VSS VDD VDD stage1_out\[179\]
+ sky130_fd_sc_hd__xnor2_1
X_08312_ _03816_ _03867_ VSS VSS VDD VDD stage1_out\[180\]
+ sky130_fd_sc_hd__xnor2_1
X_08313_ _02790_ _03858_ VSS VSS VDD VDD stage1_out\[181\]
+ sky130_fd_sc_hd__xnor2_1
X_08314_ _03815_ _03869_ VSS VSS VDD VDD stage1_out\[182\]
+ sky130_fd_sc_hd__xnor2_1
X_08315_ _02798_ _03860_ VSS VSS VDD VDD stage1_out\[183\]
+ sky130_fd_sc_hd__xnor2_1
X_08316_ _03814_ _03871_ VSS VSS VDD VDD stage1_out\[184\]
+ sky130_fd_sc_hd__xnor2_1
X_08317_ _02743_ VSS VSS VDD VDD _03891_ sky130_fd_sc_hd__inv_1
X_08318_ _02739_ VSS VSS VDD VDD _03892_ sky130_fd_sc_hd__inv_1
X_08319_ _02735_ VSS VSS VDD VDD _03893_ sky130_fd_sc_hd__inv_1
X_08320_ _02731_ VSS VSS VDD VDD _03894_ sky130_fd_sc_hd__inv_1
X_08321_ _02727_ VSS VSS VDD VDD _03895_ sky130_fd_sc_hd__inv_1
X_08322_ _02723_ VSS VSS VDD VDD _03896_ sky130_fd_sc_hd__inv_1
X_08323_ _02719_ VSS VSS VDD VDD _03897_ sky130_fd_sc_hd__inv_1
X_08324_ stage1_in_r\[112\] stage1_in_r\[80\] VSS VSS VDD
+ VDD _03898_ sky130_fd_sc_hd__nand2b_1
X_08325_ _02711_ _03898_ _02710_ VSS VSS VDD VDD _03899_ sky130_fd_sc_hd__a21o_1
X_08326_ _02715_ _03899_ _02714_ VSS VSS VDD VDD _03900_ sky130_fd_sc_hd__a21oi_1
X_08327_ _03897_ _03900_ _02718_ VSS VSS VDD VDD _03901_ sky130_fd_sc_hd__o21ba_2
X_08328_ _03896_ _03901_ _02722_ VSS VSS VDD VDD _03902_ sky130_fd_sc_hd__o21ba_2
X_08329_ _03895_ _03902_ _02726_ VSS VSS VDD VDD _03903_ sky130_fd_sc_hd__o21ba_2
X_08330_ _03894_ _03903_ _02730_ VSS VSS VDD VDD _03904_ sky130_fd_sc_hd__o21ba_2
X_08331_ _03893_ _03904_ _02734_ VSS VSS VDD VDD _03905_ sky130_fd_sc_hd__o21ba_2
X_08332_ _03892_ _03905_ _02738_ VSS VSS VDD VDD _03906_ sky130_fd_sc_hd__o21ba_2
X_08333_ _03891_ _03906_ _02742_ VSS VSS VDD VDD _03907_ sky130_fd_sc_hd__o21ba_2
X_08334_ _02747_ _03907_ VSS VSS VDD VDD stage1_out\[89\]
+ sky130_fd_sc_hd__xnor2_1
X_08335_ _02747_ VSS VSS VDD VDD _03908_ sky130_fd_sc_hd__inv_1
X_08336_ _03908_ _03907_ _02746_ VSS VSS VDD VDD _03909_ sky130_fd_sc_hd__o21ba_2
X_08337_ _02751_ _03909_ VSS VSS VDD VDD stage1_out\[90\]
+ sky130_fd_sc_hd__xnor2_1
X_08338_ _02751_ VSS VSS VDD VDD _03910_ sky130_fd_sc_hd__inv_1
X_08339_ _03910_ _03909_ _02750_ VSS VSS VDD VDD _03911_ sky130_fd_sc_hd__o21ba_2
X_08340_ _02755_ _03911_ VSS VSS VDD VDD stage1_out\[91\]
+ sky130_fd_sc_hd__xnor2_1
X_08341_ _02759_ VSS VSS VDD VDD _03912_ sky130_fd_sc_hd__inv_1
X_08342_ _02755_ VSS VSS VDD VDD _03913_ sky130_fd_sc_hd__inv_1
X_08343_ _03913_ _03911_ _02754_ VSS VSS VDD VDD _03914_ sky130_fd_sc_hd__o21bai_1
X_08344_ _03912_ _03914_ VSS VSS VDD VDD stage1_out\[92\]
+ sky130_fd_sc_hd__xnor2_1
Xinput126 in_flat[69] VSS VSS VDD VDD net125 sky130_fd_sc_hd__clkdlybuf4s50_1
X_08346_ _02759_ _03914_ _02758_ VSS VSS VDD VDD _03916_ sky130_fd_sc_hd__a21o_1
X_08347_ _02763_ _03916_ VSS VSS VDD VDD stage1_out\[93\]
+ sky130_fd_sc_hd__xor2_1
Xinput125 in_flat[68] VSS VSS VDD VDD net124 sky130_fd_sc_hd__clkdlybuf4s50_1
X_08349_ _02767_ VSS VSS VDD VDD _03918_ sky130_fd_sc_hd__inv_1
X_08350_ _02759_ _03914_ _02762_ _02758_ _03918_ VSS VSS VDD
+ VDD _03919_ sky130_fd_sc_hd__a2111o_1
X_08351_ _02767_ _02763_ VSS VSS VDD VDD _03920_ sky130_fd_sc_hd__nor2b_1
X_08352_ _02759_ _03914_ _03920_ VSS VSS VDD VDD _03921_ sky130_fd_sc_hd__nand3_1
X_08353_ _02763_ _03918_ _02762_ VSS VSS VDD VDD _03922_ sky130_fd_sc_hd__nor3_1
X_08354_ _03918_ _02762_ _03920_ _02758_ _03922_ VSS VSS VDD
+ VDD _03923_ sky130_fd_sc_hd__a221oi_1
X_08355_ _03919_ _03921_ _03923_ VSS VSS VDD VDD stage1_out\[94\]
+ sky130_fd_sc_hd__nand3_1
X_08356_ _02763_ _03918_ _02762_ _02766_ VSS VSS VDD VDD _03924_
+ sky130_fd_sc_hd__nor4_1
X_08357_ _03918_ _02766_ _03924_ VSS VSS VDD VDD _03925_ sky130_fd_sc_hd__a21oi_1
X_08358_ _03918_ _02762_ _02766_ _03916_ _03925_ VSS VSS VDD
+ VDD stage1_out\[95\] sky130_fd_sc_hd__o41ai_1
X_08359_ _02715_ VSS VSS VDD VDD _03926_ sky130_fd_sc_hd__inv_1
X_08360_ _03926_ _03899_ VSS VSS VDD VDD stage1_out\[81\]
+ sky130_fd_sc_hd__xnor2_1
X_08361_ _02719_ _03900_ VSS VSS VDD VDD stage1_out\[82\]
+ sky130_fd_sc_hd__xnor2_1
X_08362_ _02723_ _03901_ VSS VSS VDD VDD stage1_out\[83\]
+ sky130_fd_sc_hd__xnor2_1
X_08363_ _02727_ _03902_ VSS VSS VDD VDD stage1_out\[84\]
+ sky130_fd_sc_hd__xnor2_1
X_08364_ _02731_ _03903_ VSS VSS VDD VDD stage1_out\[85\]
+ sky130_fd_sc_hd__xnor2_1
X_08365_ _02735_ _03904_ VSS VSS VDD VDD stage1_out\[86\]
+ sky130_fd_sc_hd__xnor2_1
X_08366_ _02739_ _03905_ VSS VSS VDD VDD stage1_out\[87\]
+ sky130_fd_sc_hd__xnor2_1
X_08367_ _02743_ _03906_ VSS VSS VDD VDD stage1_out\[88\]
+ sky130_fd_sc_hd__xnor2_1
X_08368_ _02715_ _01062_ _02716_ VSS VSS VDD VDD _03927_ sky130_fd_sc_hd__o21bai_1
X_08369_ _03897_ _03927_ _02720_ VSS VSS VDD VDD _03928_ sky130_fd_sc_hd__a21o_1
X_08370_ _03896_ _03928_ _02724_ VSS VSS VDD VDD _03929_ sky130_fd_sc_hd__a21oi_1
X_08371_ _02727_ _03929_ _02728_ VSS VSS VDD VDD _03930_ sky130_fd_sc_hd__o21bai_1
X_08372_ _03894_ _03930_ _02732_ VSS VSS VDD VDD _03931_ sky130_fd_sc_hd__a21oi_1
X_08373_ _02735_ _03931_ _02736_ VSS VSS VDD VDD _03932_ sky130_fd_sc_hd__o21bai_1
X_08374_ _03892_ _03932_ _02740_ VSS VSS VDD VDD _03933_ sky130_fd_sc_hd__a21oi_1
X_08375_ _02743_ _03933_ _02744_ VSS VSS VDD VDD _03934_ sky130_fd_sc_hd__o21bai_1
X_08376_ _02747_ _03934_ VSS VSS VDD VDD stage1_out\[121\]
+ sky130_fd_sc_hd__xnor2_1
X_08377_ _02711_ _01061_ _02712_ VSS VSS VDD VDD _03935_ sky130_fd_sc_hd__o21bai_1
X_08378_ _03926_ _03935_ _02716_ VSS VSS VDD VDD _03936_ sky130_fd_sc_hd__a21oi_1
X_08379_ _02719_ _03936_ _02720_ VSS VSS VDD VDD _03937_ sky130_fd_sc_hd__o21bai_1
X_08380_ _03896_ _03937_ _02724_ VSS VSS VDD VDD _03938_ sky130_fd_sc_hd__a21oi_1
X_08381_ _02727_ _03938_ _02728_ VSS VSS VDD VDD _03939_ sky130_fd_sc_hd__o21bai_1
X_08382_ _03894_ _03939_ _02732_ VSS VSS VDD VDD _03940_ sky130_fd_sc_hd__a21oi_1
X_08383_ _02735_ _03940_ _02736_ VSS VSS VDD VDD _03941_ sky130_fd_sc_hd__o21bai_1
X_08384_ _03892_ _03941_ _02740_ VSS VSS VDD VDD _03942_ sky130_fd_sc_hd__a21oi_1
X_08385_ _02743_ _03942_ _02744_ VSS VSS VDD VDD _03943_ sky130_fd_sc_hd__o21bai_1
X_08386_ _03908_ _03943_ _02748_ VSS VSS VDD VDD _03944_ sky130_fd_sc_hd__a21oi_1
X_08387_ _03910_ _03944_ VSS VSS VDD VDD stage1_out\[122\]
+ sky130_fd_sc_hd__xnor2_1
X_08388_ _03908_ _03934_ _02748_ VSS VSS VDD VDD _03945_ sky130_fd_sc_hd__a21oi_1
X_08389_ _02751_ _03945_ _02752_ VSS VSS VDD VDD _03946_ sky130_fd_sc_hd__o21bai_1
X_08390_ _02755_ _03946_ VSS VSS VDD VDD stage1_out\[123\]
+ sky130_fd_sc_hd__xnor2_1
X_08391_ _02751_ _03944_ _02752_ VSS VSS VDD VDD _03947_ sky130_fd_sc_hd__o21bai_1
X_08392_ _03913_ _03947_ _02756_ VSS VSS VDD VDD _03948_ sky130_fd_sc_hd__a21oi_1
X_08393_ _03912_ _03948_ VSS VSS VDD VDD stage1_out\[124\]
+ sky130_fd_sc_hd__xnor2_1
X_08394_ _03913_ _03946_ _02756_ VSS VSS VDD VDD _03949_ sky130_fd_sc_hd__a21oi_1
X_08395_ _02759_ _03949_ VSS VSS VDD VDD _03950_ sky130_fd_sc_hd__nor2_1
X_08396_ _02760_ _03950_ VSS VSS VDD VDD _03951_ sky130_fd_sc_hd__nor2_1
X_08397_ _02763_ _03951_ VSS VSS VDD VDD stage1_out\[125\]
+ sky130_fd_sc_hd__xor2_1
X_08398_ _02760_ _02764_ VSS VSS VDD VDD _03952_ sky130_fd_sc_hd__nor2_1
X_08399_ _02759_ _03948_ _03952_ _02767_ VSS VSS VDD VDD _03953_
+ sky130_fd_sc_hd__o211a_1
X_08400_ _02759_ _02763_ _02767_ _03948_ VSS VSS VDD VDD _03954_
+ sky130_fd_sc_hd__nor4_1
X_08401_ _02764_ VSS VSS VDD VDD _03955_ sky130_fd_sc_hd__inv_1
X_08402_ _02763_ _02767_ _02760_ VSS VSS VDD VDD _03956_ sky130_fd_sc_hd__nor3b_1
X_08403_ _02763_ _03955_ _02767_ _03956_ VSS VSS VDD VDD _03957_
+ sky130_fd_sc_hd__a31oi_1
X_08404_ _03955_ _02767_ _03957_ VSS VSS VDD VDD _03958_ sky130_fd_sc_hd__o21ai_0
X_08405_ _03953_ _03954_ _03958_ VSS VSS VDD VDD stage1_out\[126\]
+ sky130_fd_sc_hd__nor3_1
X_08406_ _02764_ _02767_ _02768_ VSS VSS VDD VDD _03959_ sky130_fd_sc_hd__nor3_1
X_08407_ _02763_ _03951_ _03959_ VSS VSS VDD VDD _03960_ sky130_fd_sc_hd__o21ai_0
X_08408_ _02767_ _02768_ VSS VSS VDD VDD _03961_ sky130_fd_sc_hd__nand2_1
X_08409_ _03960_ _03961_ VSS VSS VDD VDD stage1_out\[127\]
+ sky130_fd_sc_hd__nand2_1
X_08410_ _02715_ _01062_ VSS VSS VDD VDD stage1_out\[113\]
+ sky130_fd_sc_hd__xor2_1
X_08411_ _03897_ _03936_ VSS VSS VDD VDD stage1_out\[114\]
+ sky130_fd_sc_hd__xnor2_1
X_08412_ _02723_ _03928_ VSS VSS VDD VDD stage1_out\[115\]
+ sky130_fd_sc_hd__xnor2_1
X_08413_ _03895_ _03938_ VSS VSS VDD VDD stage1_out\[116\]
+ sky130_fd_sc_hd__xnor2_1
X_08414_ _02731_ _03930_ VSS VSS VDD VDD stage1_out\[117\]
+ sky130_fd_sc_hd__xnor2_1
X_08415_ _03893_ _03940_ VSS VSS VDD VDD stage1_out\[118\]
+ sky130_fd_sc_hd__xnor2_1
X_08416_ _02739_ _03932_ VSS VSS VDD VDD stage1_out\[119\]
+ sky130_fd_sc_hd__xnor2_1
X_08417_ _03891_ _03942_ VSS VSS VDD VDD stage1_out\[120\]
+ sky130_fd_sc_hd__xnor2_1
X_08418_ _02683_ VSS VSS VDD VDD _03962_ sky130_fd_sc_hd__inv_1
X_08419_ _02675_ VSS VSS VDD VDD _03963_ sky130_fd_sc_hd__inv_1
X_08420_ _02667_ VSS VSS VDD VDD _03964_ sky130_fd_sc_hd__inv_1
X_08421_ _02659_ VSS VSS VDD VDD _03965_ sky130_fd_sc_hd__inv_1
X_08422_ _01066_ _02656_ VSS VSS VDD VDD _03966_ sky130_fd_sc_hd__nor2b_1
X_08423_ _02655_ _03966_ _02660_ VSS VSS VDD VDD _03967_ sky130_fd_sc_hd__o21ai_0
X_08424_ _02664_ VSS VSS VDD VDD _03968_ sky130_fd_sc_hd__inv_1
X_08425_ _03965_ _03967_ _03968_ VSS VSS VDD VDD _03969_ sky130_fd_sc_hd__a21oi_1
X_08426_ _02663_ _03969_ _02668_ VSS VSS VDD VDD _03970_ sky130_fd_sc_hd__o21ai_0
X_08427_ _02672_ VSS VSS VDD VDD _03971_ sky130_fd_sc_hd__inv_1
X_08428_ _03964_ _03970_ _03971_ VSS VSS VDD VDD _03972_ sky130_fd_sc_hd__a21oi_1
X_08429_ _02671_ _03972_ _02676_ VSS VSS VDD VDD _03973_ sky130_fd_sc_hd__o21ai_0
X_08430_ _02680_ VSS VSS VDD VDD _03974_ sky130_fd_sc_hd__inv_1
X_08431_ _03963_ _03973_ _03974_ VSS VSS VDD VDD _03975_ sky130_fd_sc_hd__a21oi_1
X_08432_ _02679_ _03975_ _02684_ VSS VSS VDD VDD _03976_ sky130_fd_sc_hd__o21ai_0
X_08433_ _02688_ VSS VSS VDD VDD _03977_ sky130_fd_sc_hd__inv_1
X_08434_ _03962_ _03976_ _03977_ VSS VSS VDD VDD _03978_ sky130_fd_sc_hd__a21oi_1
X_08435_ _03977_ _03962_ _03976_ VSS VSS VDD VDD _03979_ sky130_fd_sc_hd__and3_1
X_08436_ _03978_ _03979_ VSS VSS VDD VDD stage1_out\[25\]
+ sky130_fd_sc_hd__nor2_1
X_08437_ _02684_ VSS VSS VDD VDD _03980_ sky130_fd_sc_hd__inv_1
X_08438_ _02676_ VSS VSS VDD VDD _03981_ sky130_fd_sc_hd__inv_1
X_08439_ _02668_ VSS VSS VDD VDD _03982_ sky130_fd_sc_hd__inv_1
X_08440_ _02660_ VSS VSS VDD VDD _03983_ sky130_fd_sc_hd__inv_1
X_08441_ _02652_ VSS VSS VDD VDD _03984_ sky130_fd_sc_hd__inv_1
X_08442_ _03984_ _01065_ _02651_ VSS VSS VDD VDD _03985_ sky130_fd_sc_hd__o21bai_1
X_08443_ _02656_ _03985_ _02655_ VSS VSS VDD VDD _03986_ sky130_fd_sc_hd__a21oi_1
X_08444_ _03983_ _03986_ _03965_ VSS VSS VDD VDD _03987_ sky130_fd_sc_hd__o21ai_0
X_08445_ _02664_ _03987_ _02663_ VSS VSS VDD VDD _03988_ sky130_fd_sc_hd__a21oi_1
X_08446_ _03982_ _03988_ _03964_ VSS VSS VDD VDD _03989_ sky130_fd_sc_hd__o21ai_0
X_08447_ _02672_ _03989_ _02671_ VSS VSS VDD VDD _03990_ sky130_fd_sc_hd__a21oi_1
X_08448_ _03981_ _03990_ _03963_ VSS VSS VDD VDD _03991_ sky130_fd_sc_hd__o21ai_0
X_08449_ _02680_ _03991_ _02679_ VSS VSS VDD VDD _03992_ sky130_fd_sc_hd__a21oi_1
X_08450_ _03980_ _03992_ _03962_ VSS VSS VDD VDD _03993_ sky130_fd_sc_hd__o21ai_0
X_08451_ _02688_ _03993_ _02687_ VSS VSS VDD VDD _03994_ sky130_fd_sc_hd__a21oi_1
X_08452_ _02692_ _03994_ VSS VSS VDD VDD stage1_out\[26\]
+ sky130_fd_sc_hd__xnor2_1
X_08453_ _02691_ VSS VSS VDD VDD _03995_ sky130_fd_sc_hd__inv_1
X_08454_ _02687_ _03978_ _02692_ VSS VSS VDD VDD _03996_ sky130_fd_sc_hd__o21ai_0
X_08455_ _02696_ VSS VSS VDD VDD _03997_ sky130_fd_sc_hd__inv_1
X_08456_ _03995_ _03996_ _03997_ VSS VSS VDD VDD _03998_ sky130_fd_sc_hd__a21oi_1
X_08457_ _03997_ _03995_ _03996_ VSS VSS VDD VDD _03999_ sky130_fd_sc_hd__and3_1
X_08458_ _03998_ _03999_ VSS VSS VDD VDD stage1_out\[27\]
+ sky130_fd_sc_hd__nor2_1
Xinput124 in_flat[67] VSS VSS VDD VDD net123 sky130_fd_sc_hd__clkdlybuf4s50_1
X_08460_ _02692_ VSS VSS VDD VDD _04001_ sky130_fd_sc_hd__inv_1
X_08461_ _04001_ _03994_ _03995_ VSS VSS VDD VDD _04002_ sky130_fd_sc_hd__o21ai_0
X_08462_ _02696_ _04002_ _02695_ VSS VSS VDD VDD _04003_ sky130_fd_sc_hd__a21oi_1
X_08463_ _02700_ _04003_ VSS VSS VDD VDD stage1_out\[28\]
+ sky130_fd_sc_hd__xnor2_1
Xinput123 in_flat[66] VSS VSS VDD VDD net122 sky130_fd_sc_hd__clkdlybuf4s50_1
X_08465_ _02695_ _03998_ _02700_ VSS VSS VDD VDD _04005_ sky130_fd_sc_hd__o21a_1
X_08466_ _02699_ _04005_ VSS VSS VDD VDD _04006_ sky130_fd_sc_hd__nor2_1
X_08467_ _02704_ _04006_ VSS VSS VDD VDD stage1_out\[29\]
+ sky130_fd_sc_hd__xnor2_1
X_08468_ _02700_ VSS VSS VDD VDD _04007_ sky130_fd_sc_hd__inv_1
Xinput122 in_flat[65] VSS VSS VDD VDD net121 sky130_fd_sc_hd__clkdlybuf4s50_1
X_08470_ _02708_ VSS VSS VDD VDD _04009_ sky130_fd_sc_hd__inv_1
X_08471_ _04009_ _02699_ _02703_ VSS VSS VDD VDD _04010_ sky130_fd_sc_hd__nor3_1
X_08472_ _04007_ _04003_ _04010_ VSS VSS VDD VDD _04011_ sky130_fd_sc_hd__o21ai_0
X_08473_ _02708_ _02704_ VSS VSS VDD VDD _04012_ sky130_fd_sc_hd__nor2b_1
X_08474_ _04003_ _04012_ _02700_ VSS VSS VDD VDD _04013_ sky130_fd_sc_hd__nand3b_1
X_08475_ _02704_ _04009_ _02703_ VSS VSS VDD VDD _04014_ sky130_fd_sc_hd__nor3_1
X_08476_ _04009_ _02703_ _04012_ _02699_ _04014_ VSS VSS VDD
+ VDD _04015_ sky130_fd_sc_hd__a221oi_1
X_08477_ _04011_ _04013_ _04015_ VSS VSS VDD VDD stage1_out\[30\]
+ sky130_fd_sc_hd__nand3_1
X_08478_ _04006_ _02704_ VSS VSS VDD VDD _04016_ sky130_fd_sc_hd__nand2b_1
X_08479_ _04009_ _02703_ _02707_ VSS VSS VDD VDD _04017_ sky130_fd_sc_hd__nor3_1
X_08480_ _04009_ _02707_ _04016_ _04017_ VSS VSS VDD VDD stage1_out\[31\]
+ sky130_fd_sc_hd__a22o_1
X_08481_ _01066_ _02656_ VSS VSS VDD VDD stage1_out\[17\]
+ sky130_fd_sc_hd__xnor2_1
X_08482_ _02660_ _03986_ VSS VSS VDD VDD stage1_out\[18\]
+ sky130_fd_sc_hd__xnor2_1
X_08483_ _03968_ _03965_ _03967_ VSS VSS VDD VDD _04018_ sky130_fd_sc_hd__and3_1
X_08484_ _03969_ _04018_ VSS VSS VDD VDD stage1_out\[19\]
+ sky130_fd_sc_hd__nor2_1
X_08485_ _02668_ _03988_ VSS VSS VDD VDD stage1_out\[20\]
+ sky130_fd_sc_hd__xnor2_1
X_08486_ _03971_ _03964_ _03970_ VSS VSS VDD VDD _04019_ sky130_fd_sc_hd__and3_1
X_08487_ _03972_ _04019_ VSS VSS VDD VDD stage1_out\[21\]
+ sky130_fd_sc_hd__nor2_1
X_08488_ _02676_ _03990_ VSS VSS VDD VDD stage1_out\[22\]
+ sky130_fd_sc_hd__xnor2_1
X_08489_ _03974_ _03963_ _03973_ VSS VSS VDD VDD _04020_ sky130_fd_sc_hd__and3_1
X_08490_ _03975_ _04020_ VSS VSS VDD VDD stage1_out\[23\]
+ sky130_fd_sc_hd__nor2_1
X_08491_ _02684_ _03992_ VSS VSS VDD VDD stage1_out\[24\]
+ sky130_fd_sc_hd__xnor2_1
X_08492_ _02656_ _01070_ _02657_ VSS VSS VDD VDD _04021_ sky130_fd_sc_hd__o21bai_1
X_08493_ _03983_ _04021_ _02661_ VSS VSS VDD VDD _04022_ sky130_fd_sc_hd__a21o_1
X_08494_ _03968_ _04022_ _02665_ VSS VSS VDD VDD _04023_ sky130_fd_sc_hd__a21oi_1
X_08495_ _02668_ _04023_ _02669_ VSS VSS VDD VDD _04024_ sky130_fd_sc_hd__o21bai_1
X_08496_ _03971_ _04024_ _02673_ VSS VSS VDD VDD _04025_ sky130_fd_sc_hd__a21oi_1
X_08497_ _02676_ _04025_ _02677_ VSS VSS VDD VDD _04026_ sky130_fd_sc_hd__o21bai_1
X_08498_ _03974_ _04026_ _02681_ VSS VSS VDD VDD _04027_ sky130_fd_sc_hd__a21oi_1
X_08499_ _02684_ _04027_ _02685_ VSS VSS VDD VDD _04028_ sky130_fd_sc_hd__o21bai_1
X_08500_ _02688_ _04028_ VSS VSS VDD VDD stage1_out\[57\]
+ sky130_fd_sc_hd__xnor2_1
X_08501_ _02656_ VSS VSS VDD VDD _04029_ sky130_fd_sc_hd__inv_1
X_08502_ _02652_ _01069_ _02653_ VSS VSS VDD VDD _04030_ sky130_fd_sc_hd__o21bai_1
X_08503_ _04029_ _04030_ _02657_ VSS VSS VDD VDD _04031_ sky130_fd_sc_hd__a21oi_1
X_08504_ _02660_ _04031_ _02661_ VSS VSS VDD VDD _04032_ sky130_fd_sc_hd__o21bai_1
X_08505_ _03968_ _04032_ _02665_ VSS VSS VDD VDD _04033_ sky130_fd_sc_hd__a21oi_1
X_08506_ _02668_ _04033_ _02669_ VSS VSS VDD VDD _04034_ sky130_fd_sc_hd__o21bai_1
X_08507_ _03971_ _04034_ _02673_ VSS VSS VDD VDD _04035_ sky130_fd_sc_hd__a21oi_1
X_08508_ _02676_ _04035_ _02677_ VSS VSS VDD VDD _04036_ sky130_fd_sc_hd__o21bai_1
X_08509_ _03974_ _04036_ _02681_ VSS VSS VDD VDD _04037_ sky130_fd_sc_hd__a21oi_1
X_08510_ _02684_ _04037_ _02685_ VSS VSS VDD VDD _04038_ sky130_fd_sc_hd__o21bai_1
X_08511_ _03977_ _04038_ _02689_ VSS VSS VDD VDD _04039_ sky130_fd_sc_hd__a21oi_1
X_08512_ _04001_ _04039_ VSS VSS VDD VDD stage1_out\[58\]
+ sky130_fd_sc_hd__xnor2_1
X_08513_ _03977_ _04028_ _02689_ VSS VSS VDD VDD _04040_ sky130_fd_sc_hd__a21oi_1
X_08514_ _02692_ _04040_ _02693_ VSS VSS VDD VDD _04041_ sky130_fd_sc_hd__o21bai_1
X_08515_ _02696_ _04041_ VSS VSS VDD VDD stage1_out\[59\]
+ sky130_fd_sc_hd__xnor2_1
X_08516_ _02692_ _04039_ _02693_ VSS VSS VDD VDD _04042_ sky130_fd_sc_hd__o21bai_1
X_08517_ _03997_ _04042_ _02697_ VSS VSS VDD VDD _04043_ sky130_fd_sc_hd__a21oi_1
X_08518_ _04007_ _04043_ VSS VSS VDD VDD stage1_out\[60\]
+ sky130_fd_sc_hd__xnor2_1
X_08519_ _03997_ _04041_ _02697_ VSS VSS VDD VDD _04044_ sky130_fd_sc_hd__a21oi_1
X_08520_ _02700_ _04044_ VSS VSS VDD VDD _04045_ sky130_fd_sc_hd__nor2_1
X_08521_ _02701_ _04045_ VSS VSS VDD VDD _04046_ sky130_fd_sc_hd__nor2_1
X_08522_ _02704_ _04046_ VSS VSS VDD VDD stage1_out\[61\]
+ sky130_fd_sc_hd__xor2_1
X_08523_ _02701_ _02705_ VSS VSS VDD VDD _04047_ sky130_fd_sc_hd__nor2_1
X_08524_ _02700_ _04043_ _04047_ _02708_ VSS VSS VDD VDD _04048_
+ sky130_fd_sc_hd__o211a_1
X_08525_ _02700_ _02704_ _02708_ _04043_ VSS VSS VDD VDD _04049_
+ sky130_fd_sc_hd__nor4_1
X_08526_ _02705_ VSS VSS VDD VDD _04050_ sky130_fd_sc_hd__inv_1
X_08527_ _02704_ _02708_ _02701_ VSS VSS VDD VDD _04051_ sky130_fd_sc_hd__nor3b_1
X_08528_ _02704_ _04050_ _02708_ _04051_ VSS VSS VDD VDD _04052_
+ sky130_fd_sc_hd__a31oi_1
X_08529_ _04050_ _02708_ _04052_ VSS VSS VDD VDD _04053_ sky130_fd_sc_hd__o21ai_0
X_08530_ _04048_ _04049_ _04053_ VSS VSS VDD VDD stage1_out\[62\]
+ sky130_fd_sc_hd__nor3_1
X_08531_ _02705_ _02708_ _02709_ VSS VSS VDD VDD _04054_ sky130_fd_sc_hd__nor3_1
X_08532_ _02704_ _04046_ _04054_ VSS VSS VDD VDD _04055_ sky130_fd_sc_hd__o21ai_0
X_08533_ _02708_ _02709_ VSS VSS VDD VDD _04056_ sky130_fd_sc_hd__nand2_1
X_08534_ _04055_ _04056_ VSS VSS VDD VDD stage1_out\[63\]
+ sky130_fd_sc_hd__nand2_1
X_08535_ _02656_ _01070_ VSS VSS VDD VDD stage1_out\[49\]
+ sky130_fd_sc_hd__xor2_1
X_08536_ _03983_ _04031_ VSS VSS VDD VDD stage1_out\[50\]
+ sky130_fd_sc_hd__xnor2_1
X_08537_ _02664_ _04022_ VSS VSS VDD VDD stage1_out\[51\]
+ sky130_fd_sc_hd__xnor2_1
X_08538_ _03982_ _04033_ VSS VSS VDD VDD stage1_out\[52\]
+ sky130_fd_sc_hd__xnor2_1
X_08539_ _02672_ _04024_ VSS VSS VDD VDD stage1_out\[53\]
+ sky130_fd_sc_hd__xnor2_1
X_08540_ _03981_ _04035_ VSS VSS VDD VDD stage1_out\[54\]
+ sky130_fd_sc_hd__xnor2_1
X_08541_ _02680_ _04026_ VSS VSS VDD VDD stage1_out\[55\]
+ sky130_fd_sc_hd__xnor2_1
X_08542_ _03980_ _04037_ VSS VSS VDD VDD stage1_out\[56\]
+ sky130_fd_sc_hd__xnor2_1
X_08543_ _02625_ VSS VSS VDD VDD _04057_ sky130_fd_sc_hd__inv_1
X_08544_ _02621_ VSS VSS VDD VDD _04058_ sky130_fd_sc_hd__inv_1
X_08545_ _02617_ VSS VSS VDD VDD _04059_ sky130_fd_sc_hd__inv_1
X_08546_ _02613_ VSS VSS VDD VDD _04060_ sky130_fd_sc_hd__inv_1
X_08547_ _02609_ VSS VSS VDD VDD _04061_ sky130_fd_sc_hd__inv_1
X_08548_ _02605_ VSS VSS VDD VDD _04062_ sky130_fd_sc_hd__inv_1
X_08549_ _02601_ VSS VSS VDD VDD _04063_ sky130_fd_sc_hd__inv_1
X_08550_ stage2_in_r\[240\] stage2_in_r\[176\] VSS VSS VDD
+ VDD _04064_ sky130_fd_sc_hd__nand2b_1
X_08551_ _02593_ _04064_ _02592_ VSS VSS VDD VDD _04065_ sky130_fd_sc_hd__a21o_1
X_08552_ _02597_ _04065_ _02596_ VSS VSS VDD VDD _04066_ sky130_fd_sc_hd__a21oi_1
X_08553_ _04063_ _04066_ _02600_ VSS VSS VDD VDD _04067_ sky130_fd_sc_hd__o21ba_2
X_08554_ _04062_ _04067_ _02604_ VSS VSS VDD VDD _04068_ sky130_fd_sc_hd__o21ba_2
X_08555_ _04061_ _04068_ _02608_ VSS VSS VDD VDD _04069_ sky130_fd_sc_hd__o21ba_2
X_08556_ _04060_ _04069_ _02612_ VSS VSS VDD VDD _04070_ sky130_fd_sc_hd__o21ba_2
X_08557_ _04059_ _04070_ _02616_ VSS VSS VDD VDD _04071_ sky130_fd_sc_hd__o21ba_2
X_08558_ _04058_ _04071_ _02620_ VSS VSS VDD VDD _04072_ sky130_fd_sc_hd__o21ba_2
X_08559_ _04057_ _04072_ _02624_ VSS VSS VDD VDD _04073_ sky130_fd_sc_hd__o21ba_2
X_08560_ _02629_ _04073_ VSS VSS VDD VDD stage2_out\[185\]
+ sky130_fd_sc_hd__xnor2_1
X_08561_ _02629_ VSS VSS VDD VDD _04074_ sky130_fd_sc_hd__inv_1
X_08562_ _04074_ _04073_ _02628_ VSS VSS VDD VDD _04075_ sky130_fd_sc_hd__o21ba_2
X_08563_ _02633_ _04075_ VSS VSS VDD VDD stage2_out\[186\]
+ sky130_fd_sc_hd__xnor2_1
X_08564_ _02633_ VSS VSS VDD VDD _04076_ sky130_fd_sc_hd__inv_1
X_08565_ _04076_ _04075_ _02632_ VSS VSS VDD VDD _04077_ sky130_fd_sc_hd__o21ba_2
X_08566_ _02637_ _04077_ VSS VSS VDD VDD stage2_out\[187\]
+ sky130_fd_sc_hd__xnor2_1
X_08567_ _02641_ VSS VSS VDD VDD _04078_ sky130_fd_sc_hd__inv_1
X_08568_ _02637_ VSS VSS VDD VDD _04079_ sky130_fd_sc_hd__inv_1
X_08569_ _04079_ _04077_ _02636_ VSS VSS VDD VDD _04080_ sky130_fd_sc_hd__o21bai_1
X_08570_ _04078_ _04080_ VSS VSS VDD VDD stage2_out\[188\]
+ sky130_fd_sc_hd__xnor2_1
Xinput121 in_flat[64] VSS VSS VDD VDD net120 sky130_fd_sc_hd__clkdlybuf4s50_1
X_08572_ _02641_ _04080_ _02640_ VSS VSS VDD VDD _04082_ sky130_fd_sc_hd__a21o_1
X_08573_ _02645_ _04082_ VSS VSS VDD VDD stage2_out\[189\]
+ sky130_fd_sc_hd__xor2_1
Xinput120 in_flat[63] VSS VSS VDD VDD net119 sky130_fd_sc_hd__clkdlybuf4s50_1
X_08575_ _02649_ VSS VSS VDD VDD _04084_ sky130_fd_sc_hd__inv_1
X_08576_ _02641_ _04080_ _02644_ _02640_ _04084_ VSS VSS VDD
+ VDD _04085_ sky130_fd_sc_hd__a2111o_1
X_08577_ _02649_ _02645_ VSS VSS VDD VDD _04086_ sky130_fd_sc_hd__nor2b_1
X_08578_ _02641_ _04080_ _04086_ VSS VSS VDD VDD _04087_ sky130_fd_sc_hd__nand3_1
X_08579_ _02645_ _04084_ _02644_ VSS VSS VDD VDD _04088_ sky130_fd_sc_hd__nor3_1
X_08580_ _04084_ _02644_ _04086_ _02640_ _04088_ VSS VSS VDD
+ VDD _04089_ sky130_fd_sc_hd__a221oi_1
X_08581_ _04085_ _04087_ _04089_ VSS VSS VDD VDD stage2_out\[190\]
+ sky130_fd_sc_hd__nand3_1
X_08582_ _02645_ _04084_ _02644_ _02648_ VSS VSS VDD VDD _04090_
+ sky130_fd_sc_hd__nor4_1
X_08583_ _04084_ _02648_ _04090_ VSS VSS VDD VDD _04091_ sky130_fd_sc_hd__a21oi_1
X_08584_ _04084_ _02644_ _02648_ _04082_ _04091_ VSS VSS VDD
+ VDD stage2_out\[191\] sky130_fd_sc_hd__o41ai_1
X_08585_ _02597_ VSS VSS VDD VDD _04092_ sky130_fd_sc_hd__inv_1
X_08586_ _04092_ _04065_ VSS VSS VDD VDD stage2_out\[177\]
+ sky130_fd_sc_hd__xnor2_1
X_08587_ _02601_ _04066_ VSS VSS VDD VDD stage2_out\[178\]
+ sky130_fd_sc_hd__xnor2_1
X_08588_ _02605_ _04067_ VSS VSS VDD VDD stage2_out\[179\]
+ sky130_fd_sc_hd__xnor2_1
X_08589_ _02609_ _04068_ VSS VSS VDD VDD stage2_out\[180\]
+ sky130_fd_sc_hd__xnor2_1
X_08590_ _02613_ _04069_ VSS VSS VDD VDD stage2_out\[181\]
+ sky130_fd_sc_hd__xnor2_1
X_08591_ _02617_ _04070_ VSS VSS VDD VDD stage2_out\[182\]
+ sky130_fd_sc_hd__xnor2_1
X_08592_ _02621_ _04071_ VSS VSS VDD VDD stage2_out\[183\]
+ sky130_fd_sc_hd__xnor2_1
X_08593_ _02625_ _04072_ VSS VSS VDD VDD stage2_out\[184\]
+ sky130_fd_sc_hd__xnor2_1
X_08594_ _02597_ _01075_ _02598_ VSS VSS VDD VDD _04093_ sky130_fd_sc_hd__o21bai_1
X_08595_ _04063_ _04093_ _02602_ VSS VSS VDD VDD _04094_ sky130_fd_sc_hd__a21o_1
X_08596_ _04062_ _04094_ _02606_ VSS VSS VDD VDD _04095_ sky130_fd_sc_hd__a21oi_1
X_08597_ _02609_ _04095_ _02610_ VSS VSS VDD VDD _04096_ sky130_fd_sc_hd__o21bai_1
X_08598_ _04060_ _04096_ _02614_ VSS VSS VDD VDD _04097_ sky130_fd_sc_hd__a21oi_1
X_08599_ _02617_ _04097_ _02618_ VSS VSS VDD VDD _04098_ sky130_fd_sc_hd__o21bai_1
X_08600_ _04058_ _04098_ _02622_ VSS VSS VDD VDD _04099_ sky130_fd_sc_hd__a21oi_1
X_08601_ _02625_ _04099_ _02626_ VSS VSS VDD VDD _04100_ sky130_fd_sc_hd__o21bai_1
X_08602_ _02629_ _04100_ VSS VSS VDD VDD stage2_out\[249\]
+ sky130_fd_sc_hd__xnor2_1
X_08603_ _02593_ _01074_ _02594_ VSS VSS VDD VDD _04101_ sky130_fd_sc_hd__o21bai_1
X_08604_ _04092_ _04101_ _02598_ VSS VSS VDD VDD _04102_ sky130_fd_sc_hd__a21oi_1
X_08605_ _02601_ _04102_ _02602_ VSS VSS VDD VDD _04103_ sky130_fd_sc_hd__o21bai_1
X_08606_ _04062_ _04103_ _02606_ VSS VSS VDD VDD _04104_ sky130_fd_sc_hd__a21oi_1
X_08607_ _02609_ _04104_ _02610_ VSS VSS VDD VDD _04105_ sky130_fd_sc_hd__o21bai_1
X_08608_ _04060_ _04105_ _02614_ VSS VSS VDD VDD _04106_ sky130_fd_sc_hd__a21oi_1
X_08609_ _02617_ _04106_ _02618_ VSS VSS VDD VDD _04107_ sky130_fd_sc_hd__o21bai_1
X_08610_ _04058_ _04107_ _02622_ VSS VSS VDD VDD _04108_ sky130_fd_sc_hd__a21oi_1
X_08611_ _02625_ _04108_ _02626_ VSS VSS VDD VDD _04109_ sky130_fd_sc_hd__o21bai_1
X_08612_ _04074_ _04109_ _02630_ VSS VSS VDD VDD _04110_ sky130_fd_sc_hd__a21oi_1
X_08613_ _04076_ _04110_ VSS VSS VDD VDD stage2_out\[250\]
+ sky130_fd_sc_hd__xnor2_1
X_08614_ _04074_ _04100_ _02630_ VSS VSS VDD VDD _04111_ sky130_fd_sc_hd__a21oi_1
X_08615_ _02633_ _04111_ _02634_ VSS VSS VDD VDD _04112_ sky130_fd_sc_hd__o21bai_1
X_08616_ _02637_ _04112_ VSS VSS VDD VDD stage2_out\[251\]
+ sky130_fd_sc_hd__xnor2_1
X_08617_ _02633_ _04110_ _02634_ VSS VSS VDD VDD _04113_ sky130_fd_sc_hd__o21bai_1
X_08618_ _04079_ _04113_ _02638_ VSS VSS VDD VDD _04114_ sky130_fd_sc_hd__a21oi_1
X_08619_ _04078_ _04114_ VSS VSS VDD VDD stage2_out\[252\]
+ sky130_fd_sc_hd__xnor2_1
X_08620_ _04079_ _04112_ _02638_ VSS VSS VDD VDD _04115_ sky130_fd_sc_hd__a21oi_1
X_08621_ _02641_ _04115_ VSS VSS VDD VDD _04116_ sky130_fd_sc_hd__nor2_1
X_08622_ _02642_ _04116_ VSS VSS VDD VDD _04117_ sky130_fd_sc_hd__nor2_1
X_08623_ _02645_ _04117_ VSS VSS VDD VDD stage2_out\[253\]
+ sky130_fd_sc_hd__xor2_1
X_08624_ _02642_ _02646_ VSS VSS VDD VDD _04118_ sky130_fd_sc_hd__nor2_1
X_08625_ _02641_ _04114_ _04118_ _02649_ VSS VSS VDD VDD _04119_
+ sky130_fd_sc_hd__o211a_1
X_08626_ _02641_ _02645_ _02649_ _04114_ VSS VSS VDD VDD _04120_
+ sky130_fd_sc_hd__nor4_1
X_08627_ _02646_ VSS VSS VDD VDD _04121_ sky130_fd_sc_hd__inv_1
X_08628_ _02645_ _02649_ _02642_ VSS VSS VDD VDD _04122_ sky130_fd_sc_hd__nor3b_1
X_08629_ _02645_ _04121_ _02649_ _04122_ VSS VSS VDD VDD _04123_
+ sky130_fd_sc_hd__a31oi_1
X_08630_ _04121_ _02649_ _04123_ VSS VSS VDD VDD _04124_ sky130_fd_sc_hd__o21ai_0
X_08631_ _04119_ _04120_ _04124_ VSS VSS VDD VDD stage2_out\[254\]
+ sky130_fd_sc_hd__nor3_1
X_08632_ _02646_ _02649_ _02650_ VSS VSS VDD VDD _04125_ sky130_fd_sc_hd__nor3_1
X_08633_ _02645_ _04117_ _04125_ VSS VSS VDD VDD _04126_ sky130_fd_sc_hd__o21ai_0
X_08634_ _02649_ _02650_ VSS VSS VDD VDD _04127_ sky130_fd_sc_hd__nand2_1
X_08635_ _04126_ _04127_ VSS VSS VDD VDD stage2_out\[255\]
+ sky130_fd_sc_hd__nand2_1
X_08636_ _02597_ _01075_ VSS VSS VDD VDD stage2_out\[241\]
+ sky130_fd_sc_hd__xor2_1
X_08637_ _04063_ _04102_ VSS VSS VDD VDD stage2_out\[242\]
+ sky130_fd_sc_hd__xnor2_1
X_08638_ _02605_ _04094_ VSS VSS VDD VDD stage2_out\[243\]
+ sky130_fd_sc_hd__xnor2_1
X_08639_ _04061_ _04104_ VSS VSS VDD VDD stage2_out\[244\]
+ sky130_fd_sc_hd__xnor2_1
X_08640_ _02613_ _04096_ VSS VSS VDD VDD stage2_out\[245\]
+ sky130_fd_sc_hd__xnor2_1
X_08641_ _04059_ _04106_ VSS VSS VDD VDD stage2_out\[246\]
+ sky130_fd_sc_hd__xnor2_1
X_08642_ _02621_ _04098_ VSS VSS VDD VDD stage2_out\[247\]
+ sky130_fd_sc_hd__xnor2_1
X_08643_ _04057_ _04108_ VSS VSS VDD VDD stage2_out\[248\]
+ sky130_fd_sc_hd__xnor2_1
X_08644_ stage2_in_r\[146\] _02591_ VSS VSS VDD VDD _04128_
+ sky130_fd_sc_hd__nor2b_1
Xinput119 in_flat[62] VSS VSS VDD VDD net118 sky130_fd_sc_hd__clkdlybuf4s50_1
X_08646_ stage2_in_r\[147\] stage2_in_r\[148\] VSS VSS VDD
+ VDD _04130_ sky130_fd_sc_hd__nor2_1
X_08647_ stage2_in_r\[149\] stage2_in_r\[150\] VSS VSS VDD
+ VDD _04131_ sky130_fd_sc_hd__nor2_1
X_08648_ _04130_ _04131_ VSS VSS VDD VDD _04132_ sky130_fd_sc_hd__nand2_1
X_08649_ stage2_in_r\[151\] _04132_ VSS VSS VDD VDD _04133_
+ sky130_fd_sc_hd__nor2_1
X_08650_ _04128_ _04133_ VSS VSS VDD VDD _04134_ sky130_fd_sc_hd__nand2_1
X_08651_ stage2_in_r\[152\] stage2_in_r\[153\] _04134_ VSS
+ VSS VDD VDD _04135_ sky130_fd_sc_hd__nor3_1
X_08652_ stage2_in_r\[154\] _04135_ VSS VSS VDD VDD stage2_out\[201\]
+ sky130_fd_sc_hd__xnor2_1
X_08653_ stage2_in_r\[146\] stage2_in_r\[145\] stage2_in_r\[144\]
+ VSS VSS VDD VDD _04136_ sky130_fd_sc_hd__nor3_1
X_08654_ _04133_ _04136_ VSS VSS VDD VDD _04137_ sky130_fd_sc_hd__nand2_1
X_08655_ stage2_in_r\[152\] stage2_in_r\[153\] stage2_in_r\[154\]
+ _04137_ VSS VSS VDD VDD _04138_ sky130_fd_sc_hd__nor4_1
X_08656_ stage2_in_r\[155\] _04138_ VSS VSS VDD VDD stage2_out\[202\]
+ sky130_fd_sc_hd__xnor2_1
X_08657_ stage2_in_r\[154\] _04135_ VSS VSS VDD VDD _04139_
+ sky130_fd_sc_hd__nand2b_1
X_08658_ stage2_in_r\[155\] _04139_ VSS VSS VDD VDD _04140_
+ sky130_fd_sc_hd__nor2_1
X_08659_ stage2_in_r\[156\] _04140_ VSS VSS VDD VDD stage2_out\[203\]
+ sky130_fd_sc_hd__xnor2_1
X_08660_ stage2_in_r\[155\] stage2_in_r\[156\] VSS VSS VDD
+ VDD _04141_ sky130_fd_sc_hd__nor2_1
X_08661_ _04138_ _04141_ VSS VSS VDD VDD _04142_ sky130_fd_sc_hd__nand2_1
X_08662_ stage2_in_r\[157\] _04142_ VSS VSS VDD VDD stage2_out\[204\]
+ sky130_fd_sc_hd__xor2_1
X_08663_ stage2_in_r\[155\] stage2_in_r\[156\] stage2_in_r\[157\]
+ _04139_ VSS VSS VDD VDD _04143_ sky130_fd_sc_hd__nor4_1
X_08664_ stage2_in_r\[158\] _04143_ VSS VSS VDD VDD stage2_out\[205\]
+ sky130_fd_sc_hd__xnor2_1
X_08665_ stage2_in_r\[155\] stage2_in_r\[156\] stage2_in_r\[157\]
+ stage2_in_r\[158\] VSS VSS VDD VDD _04144_ sky130_fd_sc_hd__nor4_1
X_08666_ _04138_ _04144_ VSS VSS VDD VDD _04145_ sky130_fd_sc_hd__nand2_1
X_08667_ stage2_in_r\[159\] _04145_ VSS VSS VDD VDD stage2_out\[206\]
+ sky130_fd_sc_hd__xor2_1
X_08668_ _02591_ stage2_in_r\[146\] VSS VSS VDD VDD stage2_out\[193\]
+ sky130_fd_sc_hd__xnor2_1
X_08669_ stage2_in_r\[147\] _04136_ VSS VSS VDD VDD stage2_out\[194\]
+ sky130_fd_sc_hd__xnor2_1
X_08670_ stage2_in_r\[146\] _02591_ VSS VSS VDD VDD _04146_
+ sky130_fd_sc_hd__nand2b_1
X_08671_ stage2_in_r\[147\] _04146_ VSS VSS VDD VDD _04147_
+ sky130_fd_sc_hd__nor2_1
X_08672_ stage2_in_r\[148\] _04147_ VSS VSS VDD VDD stage2_out\[195\]
+ sky130_fd_sc_hd__xnor2_1
X_08673_ _04130_ _04136_ VSS VSS VDD VDD _04148_ sky130_fd_sc_hd__nand2_1
X_08674_ stage2_in_r\[149\] _04148_ VSS VSS VDD VDD stage2_out\[196\]
+ sky130_fd_sc_hd__xor2_1
X_08675_ stage2_in_r\[147\] stage2_in_r\[148\] stage2_in_r\[149\]
+ _04146_ VSS VSS VDD VDD _04149_ sky130_fd_sc_hd__nor4_1
X_08676_ stage2_in_r\[150\] _04149_ VSS VSS VDD VDD stage2_out\[197\]
+ sky130_fd_sc_hd__xnor2_1
X_08677_ _04130_ _04131_ _04136_ VSS VSS VDD VDD _04150_ sky130_fd_sc_hd__nand3_1
X_08678_ stage2_in_r\[151\] _04150_ VSS VSS VDD VDD stage2_out\[198\]
+ sky130_fd_sc_hd__xor2_1
X_08679_ stage2_in_r\[152\] _04134_ VSS VSS VDD VDD stage2_out\[199\]
+ sky130_fd_sc_hd__xor2_1
X_08680_ stage2_in_r\[152\] _04137_ VSS VSS VDD VDD _04151_
+ sky130_fd_sc_hd__nor2_1
X_08681_ stage2_in_r\[153\] _04151_ VSS VSS VDD VDD stage2_out\[200\]
+ sky130_fd_sc_hd__xnor2_1
X_08682_ stage2_in_r\[148\] stage2_in_r\[149\] stage2_in_r\[150\]
+ VSS VSS VDD VDD _04152_ sky130_fd_sc_hd__nand3_1
X_08683_ _04128_ _04131_ VSS VSS VDD VDD _04153_ sky130_fd_sc_hd__nand2_1
X_08684_ _04128_ _04152_ _04153_ stage2_in_r\[148\] VSS VSS
+ VDD VDD _04154_ sky130_fd_sc_hd__o22ai_1
X_08685_ _04136_ _04154_ VSS VSS VDD VDD _04155_ sky130_fd_sc_hd__nand2_1
X_08686_ _04136_ _04152_ VSS VSS VDD VDD _04156_ sky130_fd_sc_hd__nor2_1
X_08687_ stage2_in_r\[147\] _04156_ VSS VSS VDD VDD _04157_
+ sky130_fd_sc_hd__nand2_1
X_08688_ stage2_in_r\[147\] _04155_ _04157_ VSS VSS VDD VDD
+ _04158_ sky130_fd_sc_hd__o21ai_0
X_08689_ stage2_out\[198\] _04158_ VSS VSS VDD VDD _04159_
+ sky130_fd_sc_hd__nor2b_1
X_08690_ stage2_out\[199\] _04159_ VSS VSS VDD VDD _04160_
+ sky130_fd_sc_hd__nand2b_1
X_08691_ stage2_out\[200\] _04160_ VSS VSS VDD VDD _04161_
+ sky130_fd_sc_hd__or2_2
X_08692_ _04146_ _04161_ VSS VSS VDD VDD _04162_ sky130_fd_sc_hd__nor2_1
X_08693_ stage2_out\[201\] _04162_ VSS VSS VDD VDD stage2_out\[137\]
+ sky130_fd_sc_hd__xnor2_1
X_08694_ stage2_in_r\[144\] stage2_out\[192\] stage2_out\[193\]
+ VSS VSS VDD VDD _04163_ sky130_fd_sc_hd__or3_1
X_08695_ stage2_out\[201\] _04161_ _04163_ VSS VSS VDD VDD
+ _04164_ sky130_fd_sc_hd__nor3_1
X_08696_ stage2_out\[202\] _04164_ VSS VSS VDD VDD stage2_out\[138\]
+ sky130_fd_sc_hd__xnor2_1
X_08697_ stage2_out\[201\] stage2_out\[202\] _04161_ VSS VSS
+ VDD VDD _04165_ sky130_fd_sc_hd__or3_1
X_08698_ _04146_ _04165_ VSS VSS VDD VDD _04166_ sky130_fd_sc_hd__nor2_1
X_08699_ stage2_out\[203\] _04166_ VSS VSS VDD VDD stage2_out\[139\]
+ sky130_fd_sc_hd__xnor2_1
X_08700_ stage2_out\[203\] _04163_ _04165_ VSS VSS VDD VDD
+ _04167_ sky130_fd_sc_hd__or3_1
X_08701_ stage2_out\[204\] _04167_ VSS VSS VDD VDD stage2_out\[140\]
+ sky130_fd_sc_hd__xor2_1
X_08702_ stage2_out\[203\] stage2_out\[204\] _04165_ VSS VSS
+ VDD VDD _04168_ sky130_fd_sc_hd__nor3_1
X_08703_ _04128_ _04168_ VSS VSS VDD VDD _04169_ sky130_fd_sc_hd__nand2_1
X_08704_ stage2_out\[205\] _04169_ VSS VSS VDD VDD stage2_out\[141\]
+ sky130_fd_sc_hd__xor2_1
X_08705_ stage2_out\[205\] _04163_ VSS VSS VDD VDD _04170_
+ sky130_fd_sc_hd__nor2_1
X_08706_ _04168_ _04170_ VSS VSS VDD VDD _04171_ sky130_fd_sc_hd__nand2_1
X_08707_ stage2_out\[206\] _04171_ VSS VSS VDD VDD stage2_out\[142\]
+ sky130_fd_sc_hd__xor2_1
X_08708_ stage2_out\[205\] _04169_ VSS VSS VDD VDD _04172_
+ sky130_fd_sc_hd__nor2_1
X_08709_ stage2_out\[206\] _04172_ VSS VSS VDD VDD stage2_out\[143\]
+ sky130_fd_sc_hd__nor2_1
X_08710_ stage2_in_r\[144\] stage2_out\[192\] VSS VSS VDD
+ VDD stage2_out\[128\] sky130_fd_sc_hd__xor2_1
Xinput118 in_flat[61] VSS VSS VDD VDD net117 sky130_fd_sc_hd__clkdlybuf4s50_1
X_08712_ stage2_in_r\[144\] stage2_out\[192\] stage2_out\[193\]
+ VSS VSS VDD VDD _04173_ sky130_fd_sc_hd__nor3_1
X_08713_ stage2_out\[194\] _04173_ VSS VSS VDD VDD stage2_out\[130\]
+ sky130_fd_sc_hd__xnor2_1
X_08714_ _04146_ _04136_ VSS VSS VDD VDD _04174_ sky130_fd_sc_hd__nor2_1
X_08715_ stage2_in_r\[148\] _04174_ VSS VSS VDD VDD stage2_out\[131\]
+ sky130_fd_sc_hd__xor2_1
X_08716_ stage2_out\[194\] stage2_out\[195\] VSS VSS VDD VDD
+ _04175_ sky130_fd_sc_hd__or2_2
X_08717_ _04163_ _04175_ VSS VSS VDD VDD _04176_ sky130_fd_sc_hd__nor2_1
X_08718_ stage2_out\[196\] _04176_ VSS VSS VDD VDD stage2_out\[132\]
+ sky130_fd_sc_hd__xnor2_1
X_08719_ _04146_ stage2_out\[196\] _04175_ VSS VSS VDD VDD
+ _04177_ sky130_fd_sc_hd__nor3_1
X_08720_ stage2_out\[197\] _04177_ VSS VSS VDD VDD stage2_out\[133\]
+ sky130_fd_sc_hd__xnor2_1
X_08721_ _04158_ _04173_ VSS VSS VDD VDD _04178_ sky130_fd_sc_hd__nand2_1
X_08722_ stage2_out\[198\] _04178_ VSS VSS VDD VDD stage2_out\[134\]
+ sky130_fd_sc_hd__xor2_1
X_08723_ _04128_ _04159_ VSS VSS VDD VDD _04179_ sky130_fd_sc_hd__nand2_1
X_08724_ stage2_out\[199\] _04179_ VSS VSS VDD VDD stage2_out\[135\]
+ sky130_fd_sc_hd__xor2_1
X_08725_ _04160_ _04163_ VSS VSS VDD VDD _04180_ sky130_fd_sc_hd__nor2_1
X_08726_ stage2_out\[200\] _04180_ VSS VSS VDD VDD stage2_out\[136\]
+ sky130_fd_sc_hd__xnor2_1
X_08727_ _02562_ VSS VSS VDD VDD _04181_ sky130_fd_sc_hd__inv_1
X_08728_ _02554_ VSS VSS VDD VDD _04182_ sky130_fd_sc_hd__inv_1
X_08729_ _02546_ VSS VSS VDD VDD _04183_ sky130_fd_sc_hd__inv_1
X_08730_ _02538_ VSS VSS VDD VDD _04184_ sky130_fd_sc_hd__inv_1
X_08731_ _01079_ _02535_ VSS VSS VDD VDD _04185_ sky130_fd_sc_hd__nor2b_1
X_08732_ _02534_ _04185_ _02539_ VSS VSS VDD VDD _04186_ sky130_fd_sc_hd__o21ai_0
X_08733_ _02543_ VSS VSS VDD VDD _04187_ sky130_fd_sc_hd__inv_1
X_08734_ _04184_ _04186_ _04187_ VSS VSS VDD VDD _04188_ sky130_fd_sc_hd__a21oi_1
X_08735_ _02542_ _04188_ _02547_ VSS VSS VDD VDD _04189_ sky130_fd_sc_hd__o21ai_0
X_08736_ _02551_ VSS VSS VDD VDD _04190_ sky130_fd_sc_hd__inv_1
X_08737_ _04183_ _04189_ _04190_ VSS VSS VDD VDD _04191_ sky130_fd_sc_hd__a21oi_1
X_08738_ _02550_ _04191_ _02555_ VSS VSS VDD VDD _04192_ sky130_fd_sc_hd__o21ai_0
X_08739_ _02559_ VSS VSS VDD VDD _04193_ sky130_fd_sc_hd__inv_1
X_08740_ _04182_ _04192_ _04193_ VSS VSS VDD VDD _04194_ sky130_fd_sc_hd__a21oi_1
X_08741_ _02558_ _04194_ _02563_ VSS VSS VDD VDD _04195_ sky130_fd_sc_hd__o21ai_0
X_08742_ _02567_ VSS VSS VDD VDD _04196_ sky130_fd_sc_hd__inv_1
X_08743_ _04181_ _04195_ _04196_ VSS VSS VDD VDD _04197_ sky130_fd_sc_hd__a21oi_1
X_08744_ _04196_ _04181_ _04195_ VSS VSS VDD VDD _04198_ sky130_fd_sc_hd__and3_1
X_08745_ _04197_ _04198_ VSS VSS VDD VDD stage2_out\[57\]
+ sky130_fd_sc_hd__nor2_1
X_08746_ _02563_ VSS VSS VDD VDD _04199_ sky130_fd_sc_hd__inv_1
X_08747_ _02555_ VSS VSS VDD VDD _04200_ sky130_fd_sc_hd__inv_1
X_08748_ _02547_ VSS VSS VDD VDD _04201_ sky130_fd_sc_hd__inv_1
X_08749_ _02539_ VSS VSS VDD VDD _04202_ sky130_fd_sc_hd__inv_1
X_08750_ _02531_ VSS VSS VDD VDD _04203_ sky130_fd_sc_hd__inv_1
X_08751_ _04203_ _01078_ _02530_ VSS VSS VDD VDD _04204_ sky130_fd_sc_hd__o21bai_1
X_08752_ _02535_ _04204_ _02534_ VSS VSS VDD VDD _04205_ sky130_fd_sc_hd__a21oi_1
X_08753_ _04202_ _04205_ _04184_ VSS VSS VDD VDD _04206_ sky130_fd_sc_hd__o21ai_0
X_08754_ _02543_ _04206_ _02542_ VSS VSS VDD VDD _04207_ sky130_fd_sc_hd__a21oi_1
X_08755_ _04201_ _04207_ _04183_ VSS VSS VDD VDD _04208_ sky130_fd_sc_hd__o21ai_0
X_08756_ _02551_ _04208_ _02550_ VSS VSS VDD VDD _04209_ sky130_fd_sc_hd__a21oi_1
X_08757_ _04200_ _04209_ _04182_ VSS VSS VDD VDD _04210_ sky130_fd_sc_hd__o21ai_0
X_08758_ _02559_ _04210_ _02558_ VSS VSS VDD VDD _04211_ sky130_fd_sc_hd__a21oi_1
X_08759_ _04199_ _04211_ _04181_ VSS VSS VDD VDD _04212_ sky130_fd_sc_hd__o21ai_0
X_08760_ _02567_ _04212_ _02566_ VSS VSS VDD VDD _04213_ sky130_fd_sc_hd__a21oi_1
X_08761_ _02571_ _04213_ VSS VSS VDD VDD stage2_out\[58\]
+ sky130_fd_sc_hd__xnor2_1
X_08762_ _02570_ VSS VSS VDD VDD _04214_ sky130_fd_sc_hd__inv_1
X_08763_ _02566_ _04197_ _02571_ VSS VSS VDD VDD _04215_ sky130_fd_sc_hd__o21ai_0
X_08764_ _02575_ VSS VSS VDD VDD _04216_ sky130_fd_sc_hd__inv_1
X_08765_ _04214_ _04215_ _04216_ VSS VSS VDD VDD _04217_ sky130_fd_sc_hd__a21oi_1
X_08766_ _04216_ _04214_ _04215_ VSS VSS VDD VDD _04218_ sky130_fd_sc_hd__and3_1
X_08767_ _04217_ _04218_ VSS VSS VDD VDD stage2_out\[59\]
+ sky130_fd_sc_hd__nor2_1
Xinput117 in_flat[60] VSS VSS VDD VDD net116 sky130_fd_sc_hd__clkdlybuf4s50_1
X_08769_ _02571_ VSS VSS VDD VDD _04220_ sky130_fd_sc_hd__inv_1
X_08770_ _04220_ _04213_ _04214_ VSS VSS VDD VDD _04221_ sky130_fd_sc_hd__o21ai_0
X_08771_ _02575_ _04221_ _02574_ VSS VSS VDD VDD _04222_ sky130_fd_sc_hd__a21oi_1
X_08772_ _02579_ _04222_ VSS VSS VDD VDD stage2_out\[60\]
+ sky130_fd_sc_hd__xnor2_1
Xinput116 in_flat[5] VSS VSS VDD VDD net115 sky130_fd_sc_hd__clkdlybuf4s50_1
X_08774_ _02574_ _04217_ _02579_ VSS VSS VDD VDD _04224_ sky130_fd_sc_hd__o21a_1
X_08775_ _02578_ _04224_ VSS VSS VDD VDD _04225_ sky130_fd_sc_hd__nor2_1
X_08776_ _02583_ _04225_ VSS VSS VDD VDD stage2_out\[61\]
+ sky130_fd_sc_hd__xnor2_1
X_08777_ _02579_ VSS VSS VDD VDD _04226_ sky130_fd_sc_hd__inv_1
Xinput115 in_flat[59] VSS VSS VDD VDD net114 sky130_fd_sc_hd__clkdlybuf4s50_1
X_08779_ _02587_ VSS VSS VDD VDD _04228_ sky130_fd_sc_hd__inv_1
X_08780_ _04228_ _02578_ _02582_ VSS VSS VDD VDD _04229_ sky130_fd_sc_hd__nor3_1
X_08781_ _04226_ _04222_ _04229_ VSS VSS VDD VDD _04230_ sky130_fd_sc_hd__o21ai_0
X_08782_ _02587_ _02583_ VSS VSS VDD VDD _04231_ sky130_fd_sc_hd__nor2b_1
X_08783_ _04222_ _04231_ _02579_ VSS VSS VDD VDD _04232_ sky130_fd_sc_hd__nand3b_1
X_08784_ _02583_ _04228_ _02582_ VSS VSS VDD VDD _04233_ sky130_fd_sc_hd__nor3_1
X_08785_ _04228_ _02582_ _04231_ _02578_ _04233_ VSS VSS VDD
+ VDD _04234_ sky130_fd_sc_hd__a221oi_1
X_08786_ _04230_ _04232_ _04234_ VSS VSS VDD VDD stage2_out\[62\]
+ sky130_fd_sc_hd__nand3_1
X_08787_ _04225_ _02583_ VSS VSS VDD VDD _04235_ sky130_fd_sc_hd__nand2b_1
X_08788_ _04228_ _02582_ _02586_ VSS VSS VDD VDD _04236_ sky130_fd_sc_hd__nor3_1
X_08789_ _04228_ _02586_ _04235_ _04236_ VSS VSS VDD VDD stage2_out\[63\]
+ sky130_fd_sc_hd__a22o_1
X_08790_ _01079_ _02535_ VSS VSS VDD VDD stage2_out\[49\]
+ sky130_fd_sc_hd__xnor2_1
X_08791_ _02539_ _04205_ VSS VSS VDD VDD stage2_out\[50\]
+ sky130_fd_sc_hd__xnor2_1
X_08792_ _04187_ _04184_ _04186_ VSS VSS VDD VDD _04237_ sky130_fd_sc_hd__and3_1
X_08793_ _04188_ _04237_ VSS VSS VDD VDD stage2_out\[51\]
+ sky130_fd_sc_hd__nor2_1
X_08794_ _02547_ _04207_ VSS VSS VDD VDD stage2_out\[52\]
+ sky130_fd_sc_hd__xnor2_1
X_08795_ _04190_ _04183_ _04189_ VSS VSS VDD VDD _04238_ sky130_fd_sc_hd__and3_1
X_08796_ _04191_ _04238_ VSS VSS VDD VDD stage2_out\[53\]
+ sky130_fd_sc_hd__nor2_1
X_08797_ _02555_ _04209_ VSS VSS VDD VDD stage2_out\[54\]
+ sky130_fd_sc_hd__xnor2_1
X_08798_ _04193_ _04182_ _04192_ VSS VSS VDD VDD _04239_ sky130_fd_sc_hd__and3_1
X_08799_ _04194_ _04239_ VSS VSS VDD VDD stage2_out\[55\]
+ sky130_fd_sc_hd__nor2_1
X_08800_ _02563_ _04211_ VSS VSS VDD VDD stage2_out\[56\]
+ sky130_fd_sc_hd__xnor2_1
X_08801_ _02535_ _01083_ _02536_ VSS VSS VDD VDD _04240_ sky130_fd_sc_hd__o21bai_1
X_08802_ _04202_ _04240_ _02540_ VSS VSS VDD VDD _04241_ sky130_fd_sc_hd__a21o_1
X_08803_ _04187_ _04241_ _02544_ VSS VSS VDD VDD _04242_ sky130_fd_sc_hd__a21oi_1
X_08804_ _02547_ _04242_ _02548_ VSS VSS VDD VDD _04243_ sky130_fd_sc_hd__o21bai_1
X_08805_ _04190_ _04243_ _02552_ VSS VSS VDD VDD _04244_ sky130_fd_sc_hd__a21oi_1
X_08806_ _02555_ _04244_ _02556_ VSS VSS VDD VDD _04245_ sky130_fd_sc_hd__o21bai_1
X_08807_ _04193_ _04245_ _02560_ VSS VSS VDD VDD _04246_ sky130_fd_sc_hd__a21oi_1
X_08808_ _02563_ _04246_ _02564_ VSS VSS VDD VDD _04247_ sky130_fd_sc_hd__o21bai_1
X_08809_ _02567_ _04247_ VSS VSS VDD VDD stage2_out\[121\]
+ sky130_fd_sc_hd__xnor2_1
X_08810_ _02535_ VSS VSS VDD VDD _04248_ sky130_fd_sc_hd__inv_1
X_08811_ _02531_ _01082_ _02532_ VSS VSS VDD VDD _04249_ sky130_fd_sc_hd__o21bai_1
X_08812_ _04248_ _04249_ _02536_ VSS VSS VDD VDD _04250_ sky130_fd_sc_hd__a21oi_1
X_08813_ _02539_ _04250_ _02540_ VSS VSS VDD VDD _04251_ sky130_fd_sc_hd__o21bai_1
X_08814_ _04187_ _04251_ _02544_ VSS VSS VDD VDD _04252_ sky130_fd_sc_hd__a21oi_1
X_08815_ _02547_ _04252_ _02548_ VSS VSS VDD VDD _04253_ sky130_fd_sc_hd__o21bai_1
X_08816_ _04190_ _04253_ _02552_ VSS VSS VDD VDD _04254_ sky130_fd_sc_hd__a21oi_1
X_08817_ _02555_ _04254_ _02556_ VSS VSS VDD VDD _04255_ sky130_fd_sc_hd__o21bai_1
X_08818_ _04193_ _04255_ _02560_ VSS VSS VDD VDD _04256_ sky130_fd_sc_hd__a21oi_1
X_08819_ _02563_ _04256_ _02564_ VSS VSS VDD VDD _04257_ sky130_fd_sc_hd__o21bai_1
X_08820_ _04196_ _04257_ _02568_ VSS VSS VDD VDD _04258_ sky130_fd_sc_hd__a21oi_1
X_08821_ _04220_ _04258_ VSS VSS VDD VDD stage2_out\[122\]
+ sky130_fd_sc_hd__xnor2_1
X_08822_ _04196_ _04247_ _02568_ VSS VSS VDD VDD _04259_ sky130_fd_sc_hd__a21oi_1
X_08823_ _02571_ _04259_ _02572_ VSS VSS VDD VDD _04260_ sky130_fd_sc_hd__o21bai_1
X_08824_ _02575_ _04260_ VSS VSS VDD VDD stage2_out\[123\]
+ sky130_fd_sc_hd__xnor2_1
X_08825_ _02571_ _04258_ _02572_ VSS VSS VDD VDD _04261_ sky130_fd_sc_hd__o21bai_1
X_08826_ _04216_ _04261_ _02576_ VSS VSS VDD VDD _04262_ sky130_fd_sc_hd__a21oi_1
X_08827_ _04226_ _04262_ VSS VSS VDD VDD stage2_out\[124\]
+ sky130_fd_sc_hd__xnor2_1
X_08828_ _04216_ _04260_ _02576_ VSS VSS VDD VDD _04263_ sky130_fd_sc_hd__a21oi_1
X_08829_ _02579_ _04263_ VSS VSS VDD VDD _04264_ sky130_fd_sc_hd__nor2_1
X_08830_ _02580_ _04264_ VSS VSS VDD VDD _04265_ sky130_fd_sc_hd__nor2_1
X_08831_ _02583_ _04265_ VSS VSS VDD VDD stage2_out\[125\]
+ sky130_fd_sc_hd__xor2_1
X_08832_ _02580_ _02584_ VSS VSS VDD VDD _04266_ sky130_fd_sc_hd__nor2_1
X_08833_ _02579_ _04262_ _04266_ _02587_ VSS VSS VDD VDD _04267_
+ sky130_fd_sc_hd__o211a_1
X_08834_ _02579_ _02583_ _02587_ _04262_ VSS VSS VDD VDD _04268_
+ sky130_fd_sc_hd__nor4_1
X_08835_ _02584_ VSS VSS VDD VDD _04269_ sky130_fd_sc_hd__inv_1
X_08836_ _02583_ _02587_ _02580_ VSS VSS VDD VDD _04270_ sky130_fd_sc_hd__nor3b_1
X_08837_ _02583_ _04269_ _02587_ _04270_ VSS VSS VDD VDD _04271_
+ sky130_fd_sc_hd__a31oi_1
X_08838_ _04269_ _02587_ _04271_ VSS VSS VDD VDD _04272_ sky130_fd_sc_hd__o21ai_0
X_08839_ _04267_ _04268_ _04272_ VSS VSS VDD VDD stage2_out\[126\]
+ sky130_fd_sc_hd__nor3_1
X_08840_ _02584_ _02587_ _02588_ VSS VSS VDD VDD _04273_ sky130_fd_sc_hd__nor3_1
X_08841_ _02583_ _04265_ _04273_ VSS VSS VDD VDD _04274_ sky130_fd_sc_hd__o21ai_0
X_08842_ _02587_ _02588_ VSS VSS VDD VDD _04275_ sky130_fd_sc_hd__nand2_1
X_08843_ _04274_ _04275_ VSS VSS VDD VDD stage2_out\[127\]
+ sky130_fd_sc_hd__nand2_1
X_08844_ _02535_ _01083_ VSS VSS VDD VDD stage2_out\[113\]
+ sky130_fd_sc_hd__xor2_1
X_08845_ _04202_ _04250_ VSS VSS VDD VDD stage2_out\[114\]
+ sky130_fd_sc_hd__xnor2_1
X_08846_ _02543_ _04241_ VSS VSS VDD VDD stage2_out\[115\]
+ sky130_fd_sc_hd__xnor2_1
X_08847_ _04201_ _04252_ VSS VSS VDD VDD stage2_out\[116\]
+ sky130_fd_sc_hd__xnor2_1
X_08848_ _02551_ _04243_ VSS VSS VDD VDD stage2_out\[117\]
+ sky130_fd_sc_hd__xnor2_1
X_08849_ _04200_ _04254_ VSS VSS VDD VDD stage2_out\[118\]
+ sky130_fd_sc_hd__xnor2_1
X_08850_ _02559_ _04245_ VSS VSS VDD VDD stage2_out\[119\]
+ sky130_fd_sc_hd__xnor2_1
X_08851_ _04199_ _04256_ VSS VSS VDD VDD stage2_out\[120\]
+ sky130_fd_sc_hd__xnor2_1
X_08852_ stage2_in_r\[19\] stage2_in_r\[20\] stage2_in_r\[21\]
+ stage2_in_r\[22\] VSS VSS VDD VDD _04276_ sky130_fd_sc_hd__or4_1
X_08853_ stage2_in_r\[18\] _02529_ VSS VSS VDD VDD _04277_
+ sky130_fd_sc_hd__nand2b_1
X_08854_ stage2_in_r\[23\] _04276_ _04277_ VSS VSS VDD VDD
+ _04278_ sky130_fd_sc_hd__nor3_1
X_08855_ stage2_in_r\[24\] stage2_in_r\[25\] VSS VSS VDD VDD
+ _04279_ sky130_fd_sc_hd__nor2_1
X_08856_ _04278_ _04279_ VSS VSS VDD VDD _04280_ sky130_fd_sc_hd__nand2_1
X_08857_ stage2_in_r\[26\] _04280_ VSS VSS VDD VDD stage2_out\[73\]
+ sky130_fd_sc_hd__xor2_1
X_08858_ stage2_in_r\[18\] stage2_in_r\[17\] stage2_in_r\[16\]
+ VSS VSS VDD VDD _04281_ sky130_fd_sc_hd__nor3_1
X_08859_ _04276_ _04281_ VSS VSS VDD VDD _04282_ sky130_fd_sc_hd__nor2b_1
X_08860_ stage2_in_r\[23\] _04282_ VSS VSS VDD VDD _04283_
+ sky130_fd_sc_hd__nand2b_1
X_08861_ stage2_in_r\[24\] stage2_in_r\[25\] stage2_in_r\[26\]
+ _04283_ VSS VSS VDD VDD _04284_ sky130_fd_sc_hd__nor4_1
X_08862_ stage2_in_r\[27\] _04284_ VSS VSS VDD VDD stage2_out\[74\]
+ sky130_fd_sc_hd__xnor2_1
X_08863_ stage2_in_r\[26\] _04278_ _04279_ VSS VSS VDD VDD
+ _04285_ sky130_fd_sc_hd__nand3b_1
X_08864_ stage2_in_r\[27\] _04285_ VSS VSS VDD VDD _04286_
+ sky130_fd_sc_hd__nor2_1
X_08865_ stage2_in_r\[28\] _04286_ VSS VSS VDD VDD stage2_out\[75\]
+ sky130_fd_sc_hd__xnor2_1
X_08866_ stage2_in_r\[27\] stage2_in_r\[28\] VSS VSS VDD VDD
+ _04287_ sky130_fd_sc_hd__nor2_1
X_08867_ _04284_ _04287_ VSS VSS VDD VDD _04288_ sky130_fd_sc_hd__nand2_1
X_08868_ stage2_in_r\[29\] _04288_ VSS VSS VDD VDD stage2_out\[76\]
+ sky130_fd_sc_hd__xor2_1
X_08869_ stage2_in_r\[27\] stage2_in_r\[28\] stage2_in_r\[29\]
+ _04285_ VSS VSS VDD VDD _04289_ sky130_fd_sc_hd__nor4_1
X_08870_ stage2_in_r\[30\] _04289_ VSS VSS VDD VDD stage2_out\[77\]
+ sky130_fd_sc_hd__xnor2_1
X_08871_ stage2_in_r\[27\] stage2_in_r\[28\] stage2_in_r\[29\]
+ stage2_in_r\[30\] VSS VSS VDD VDD _04290_ sky130_fd_sc_hd__nor4_1
X_08872_ _04284_ _04290_ VSS VSS VDD VDD _04291_ sky130_fd_sc_hd__nand2_1
X_08873_ stage2_in_r\[31\] _04291_ VSS VSS VDD VDD stage2_out\[78\]
+ sky130_fd_sc_hd__xor2_1
X_08874_ _02529_ stage2_in_r\[18\] VSS VSS VDD VDD stage2_out\[65\]
+ sky130_fd_sc_hd__xnor2_1
X_08875_ stage2_in_r\[19\] _04281_ VSS VSS VDD VDD stage2_out\[66\]
+ sky130_fd_sc_hd__xnor2_1
X_08876_ stage2_in_r\[19\] _04277_ VSS VSS VDD VDD _04292_
+ sky130_fd_sc_hd__nor2_1
X_08877_ stage2_in_r\[20\] _04292_ VSS VSS VDD VDD stage2_out\[67\]
+ sky130_fd_sc_hd__xnor2_1
X_08878_ stage2_in_r\[19\] stage2_in_r\[20\] VSS VSS VDD VDD
+ _04293_ sky130_fd_sc_hd__nor2_1
X_08879_ _04293_ _04281_ VSS VSS VDD VDD _04294_ sky130_fd_sc_hd__nand2_1
X_08880_ stage2_in_r\[21\] _04294_ VSS VSS VDD VDD stage2_out\[68\]
+ sky130_fd_sc_hd__xor2_1
X_08881_ stage2_in_r\[19\] stage2_in_r\[20\] stage2_in_r\[21\]
+ _04277_ VSS VSS VDD VDD _04295_ sky130_fd_sc_hd__nor4_1
X_08882_ stage2_in_r\[22\] _04295_ VSS VSS VDD VDD stage2_out\[69\]
+ sky130_fd_sc_hd__xnor2_1
X_08883_ stage2_in_r\[23\] _04282_ VSS VSS VDD VDD stage2_out\[70\]
+ sky130_fd_sc_hd__xnor2_1
X_08884_ stage2_in_r\[24\] _04278_ VSS VSS VDD VDD stage2_out\[71\]
+ sky130_fd_sc_hd__xnor2_1
X_08885_ stage2_in_r\[24\] _04283_ VSS VSS VDD VDD _04296_
+ sky130_fd_sc_hd__nor2_1
X_08886_ stage2_in_r\[25\] _04296_ VSS VSS VDD VDD stage2_out\[72\]
+ sky130_fd_sc_hd__xnor2_1
X_08887_ _04277_ stage2_out\[66\] stage2_out\[67\] VSS VSS
+ VDD VDD _04297_ sky130_fd_sc_hd__or3_1
X_08888_ stage2_out\[68\] stage2_out\[69\] stage2_out\[70\]
+ VSS VSS VDD VDD _04298_ sky130_fd_sc_hd__or3_1
X_08889_ stage2_out\[71\] _04298_ VSS VSS VDD VDD _04299_
+ sky130_fd_sc_hd__or2_2
X_08890_ stage2_out\[72\] _04297_ _04299_ VSS VSS VDD VDD
+ _04300_ sky130_fd_sc_hd__nor3_1
X_08891_ stage2_out\[73\] _04300_ VSS VSS VDD VDD stage2_out\[9\]
+ sky130_fd_sc_hd__xnor2_1
X_08892_ stage2_out\[66\] stage2_out\[67\] VSS VSS VDD VDD
+ _04301_ sky130_fd_sc_hd__nor2_1
X_08893_ stage2_in_r\[16\] stage2_out\[64\] stage2_out\[65\]
+ VSS VSS VDD VDD _04302_ sky130_fd_sc_hd__nor3_1
X_08894_ _04301_ _04302_ VSS VSS VDD VDD _04303_ sky130_fd_sc_hd__nand2_1
X_08895_ stage2_out\[73\] stage2_out\[72\] _04299_ VSS VSS
+ VDD VDD _04304_ sky130_fd_sc_hd__or3_1
X_08896_ _04303_ _04304_ VSS VSS VDD VDD _04305_ sky130_fd_sc_hd__nor2_1
X_08897_ stage2_out\[74\] _04305_ VSS VSS VDD VDD stage2_out\[10\]
+ sky130_fd_sc_hd__xnor2_1
X_08898_ stage2_out\[74\] _04297_ _04304_ VSS VSS VDD VDD
+ _04306_ sky130_fd_sc_hd__or3_1
X_08899_ stage2_out\[75\] _04306_ VSS VSS VDD VDD stage2_out\[11\]
+ sky130_fd_sc_hd__xor2_1
X_08900_ stage2_out\[74\] stage2_out\[75\] _04303_ _04304_
+ VSS VSS VDD VDD _04307_ sky130_fd_sc_hd__nor4_1
X_08901_ stage2_out\[76\] _04307_ VSS VSS VDD VDD stage2_out\[12\]
+ sky130_fd_sc_hd__xnor2_1
X_08902_ stage2_out\[75\] stage2_out\[76\] _04306_ stage2_out\[77\]
+ VSS VSS VDD VDD _04308_ sky130_fd_sc_hd__o31a_1
X_08903_ stage2_out\[75\] stage2_out\[76\] stage2_out\[77\]
+ _04306_ VSS VSS VDD VDD _04309_ sky130_fd_sc_hd__nor4_1
X_08904_ _04308_ _04309_ VSS VSS VDD VDD stage2_out\[13\]
+ sky130_fd_sc_hd__nor2_1
X_08905_ stage2_out\[76\] stage2_out\[77\] VSS VSS VDD VDD
+ _04310_ sky130_fd_sc_hd__nor2_1
X_08906_ _04307_ _04310_ VSS VSS VDD VDD _04311_ sky130_fd_sc_hd__nand2_1
X_08907_ stage2_out\[78\] _04311_ VSS VSS VDD VDD stage2_out\[14\]
+ sky130_fd_sc_hd__xor2_1
X_08908_ stage2_out\[78\] _04309_ VSS VSS VDD VDD stage2_out\[15\]
+ sky130_fd_sc_hd__nor2_1
X_08909_ stage2_in_r\[16\] stage2_out\[64\] VSS VSS VDD VDD
+ stage2_out\[0\] sky130_fd_sc_hd__xor2_1
Xinput114 in_flat[58] VSS VSS VDD VDD net113 sky130_fd_sc_hd__clkdlybuf4s50_1
X_08911_ stage2_out\[66\] _04302_ VSS VSS VDD VDD stage2_out\[2\]
+ sky130_fd_sc_hd__xnor2_1
X_08912_ _04277_ _04281_ VSS VSS VDD VDD _04312_ sky130_fd_sc_hd__nor2_1
X_08913_ stage2_in_r\[20\] _04312_ VSS VSS VDD VDD stage2_out\[3\]
+ sky130_fd_sc_hd__xor2_1
X_08914_ stage2_out\[68\] _04303_ VSS VSS VDD VDD stage2_out\[4\]
+ sky130_fd_sc_hd__xor2_1
X_08915_ stage2_out\[68\] _04297_ VSS VSS VDD VDD _04313_
+ sky130_fd_sc_hd__nor2_1
X_08916_ stage2_out\[69\] _04313_ VSS VSS VDD VDD stage2_out\[5\]
+ sky130_fd_sc_hd__xnor2_1
X_08917_ stage2_out\[68\] stage2_out\[69\] _04303_ VSS VSS
+ VDD VDD _04314_ sky130_fd_sc_hd__nor3_1
X_08918_ stage2_out\[70\] _04314_ VSS VSS VDD VDD stage2_out\[6\]
+ sky130_fd_sc_hd__xnor2_1
X_08919_ _04297_ _04298_ VSS VSS VDD VDD _04315_ sky130_fd_sc_hd__nor2_1
X_08920_ stage2_out\[71\] _04315_ VSS VSS VDD VDD stage2_out\[7\]
+ sky130_fd_sc_hd__xnor2_1
X_08921_ _04299_ _04303_ VSS VSS VDD VDD _04316_ sky130_fd_sc_hd__nor2_1
X_08922_ stage2_out\[72\] _04316_ VSS VSS VDD VDD stage2_out\[8\]
+ sky130_fd_sc_hd__xnor2_1
X_08923_ _02500_ VSS VSS VDD VDD _04317_ sky130_fd_sc_hd__inv_1
X_08924_ _02492_ VSS VSS VDD VDD _04318_ sky130_fd_sc_hd__inv_1
X_08925_ _02484_ VSS VSS VDD VDD _04319_ sky130_fd_sc_hd__inv_1
X_08926_ _02476_ VSS VSS VDD VDD _04320_ sky130_fd_sc_hd__inv_1
X_08927_ _01087_ _02473_ VSS VSS VDD VDD _04321_ sky130_fd_sc_hd__nor2b_1
X_08928_ _02472_ _04321_ _02477_ VSS VSS VDD VDD _04322_ sky130_fd_sc_hd__o21ai_0
X_08929_ _02481_ VSS VSS VDD VDD _04323_ sky130_fd_sc_hd__inv_1
X_08930_ _04320_ _04322_ _04323_ VSS VSS VDD VDD _04324_ sky130_fd_sc_hd__a21oi_1
X_08931_ _02480_ _04324_ _02485_ VSS VSS VDD VDD _04325_ sky130_fd_sc_hd__o21ai_0
X_08932_ _02489_ VSS VSS VDD VDD _04326_ sky130_fd_sc_hd__inv_1
X_08933_ _04319_ _04325_ _04326_ VSS VSS VDD VDD _04327_ sky130_fd_sc_hd__a21oi_1
X_08934_ _02488_ _04327_ _02493_ VSS VSS VDD VDD _04328_ sky130_fd_sc_hd__o21ai_0
X_08935_ _02497_ VSS VSS VDD VDD _04329_ sky130_fd_sc_hd__inv_1
X_08936_ _04318_ _04328_ _04329_ VSS VSS VDD VDD _04330_ sky130_fd_sc_hd__a21oi_1
X_08937_ _02496_ _04330_ _02501_ VSS VSS VDD VDD _04331_ sky130_fd_sc_hd__o21ai_0
X_08938_ _02505_ VSS VSS VDD VDD _04332_ sky130_fd_sc_hd__inv_1
X_08939_ _04317_ _04331_ _04332_ VSS VSS VDD VDD _04333_ sky130_fd_sc_hd__a21oi_1
X_08940_ _04332_ _04317_ _04331_ VSS VSS VDD VDD _04334_ sky130_fd_sc_hd__and3_1
X_08941_ _04333_ _04334_ VSS VSS VDD VDD stage3_out\[121\]
+ sky130_fd_sc_hd__nor2_1
X_08942_ _02501_ VSS VSS VDD VDD _04335_ sky130_fd_sc_hd__inv_1
X_08943_ _02493_ VSS VSS VDD VDD _04336_ sky130_fd_sc_hd__inv_1
X_08944_ _02485_ VSS VSS VDD VDD _04337_ sky130_fd_sc_hd__inv_1
X_08945_ _02477_ VSS VSS VDD VDD _04338_ sky130_fd_sc_hd__inv_1
X_08946_ _02469_ VSS VSS VDD VDD _04339_ sky130_fd_sc_hd__inv_1
X_08947_ _04339_ _01086_ _02468_ VSS VSS VDD VDD _04340_ sky130_fd_sc_hd__o21bai_1
X_08948_ _02473_ _04340_ _02472_ VSS VSS VDD VDD _04341_ sky130_fd_sc_hd__a21oi_1
X_08949_ _04338_ _04341_ _04320_ VSS VSS VDD VDD _04342_ sky130_fd_sc_hd__o21ai_0
X_08950_ _02481_ _04342_ _02480_ VSS VSS VDD VDD _04343_ sky130_fd_sc_hd__a21oi_1
X_08951_ _04337_ _04343_ _04319_ VSS VSS VDD VDD _04344_ sky130_fd_sc_hd__o21ai_0
X_08952_ _02489_ _04344_ _02488_ VSS VSS VDD VDD _04345_ sky130_fd_sc_hd__a21oi_1
X_08953_ _04336_ _04345_ _04318_ VSS VSS VDD VDD _04346_ sky130_fd_sc_hd__o21ai_0
X_08954_ _02497_ _04346_ _02496_ VSS VSS VDD VDD _04347_ sky130_fd_sc_hd__a21oi_1
X_08955_ _04335_ _04347_ _04317_ VSS VSS VDD VDD _04348_ sky130_fd_sc_hd__o21ai_0
X_08956_ _02505_ _04348_ _02504_ VSS VSS VDD VDD _04349_ sky130_fd_sc_hd__a21oi_1
X_08957_ _02509_ _04349_ VSS VSS VDD VDD stage3_out\[122\]
+ sky130_fd_sc_hd__xnor2_1
X_08958_ _02508_ VSS VSS VDD VDD _04350_ sky130_fd_sc_hd__inv_1
X_08959_ _02504_ _04333_ _02509_ VSS VSS VDD VDD _04351_ sky130_fd_sc_hd__o21ai_0
X_08960_ _02513_ VSS VSS VDD VDD _04352_ sky130_fd_sc_hd__inv_1
X_08961_ _04350_ _04351_ _04352_ VSS VSS VDD VDD _04353_ sky130_fd_sc_hd__a21oi_1
X_08962_ _04352_ _04350_ _04351_ VSS VSS VDD VDD _04354_ sky130_fd_sc_hd__and3_1
X_08963_ _04353_ _04354_ VSS VSS VDD VDD stage3_out\[123\]
+ sky130_fd_sc_hd__nor2_1
Xinput113 in_flat[57] VSS VSS VDD VDD net112 sky130_fd_sc_hd__clkdlybuf4s50_1
X_08965_ _02509_ VSS VSS VDD VDD _04356_ sky130_fd_sc_hd__inv_1
X_08966_ _04356_ _04349_ _04350_ VSS VSS VDD VDD _04357_ sky130_fd_sc_hd__o21ai_0
X_08967_ _02513_ _04357_ _02512_ VSS VSS VDD VDD _04358_ sky130_fd_sc_hd__a21oi_1
X_08968_ _02517_ _04358_ VSS VSS VDD VDD stage3_out\[124\]
+ sky130_fd_sc_hd__xnor2_1
Xinput112 in_flat[56] VSS VSS VDD VDD net111 sky130_fd_sc_hd__clkdlybuf4s50_1
X_08970_ _02512_ _04353_ _02517_ VSS VSS VDD VDD _04360_ sky130_fd_sc_hd__o21a_1
X_08971_ _02516_ _04360_ VSS VSS VDD VDD _04361_ sky130_fd_sc_hd__nor2_1
X_08972_ _02521_ _04361_ VSS VSS VDD VDD stage3_out\[125\]
+ sky130_fd_sc_hd__xnor2_1
X_08973_ _02517_ VSS VSS VDD VDD _04362_ sky130_fd_sc_hd__inv_1
Xinput111 in_flat[55] VSS VSS VDD VDD net110 sky130_fd_sc_hd__clkdlybuf4s50_1
X_08975_ _02525_ VSS VSS VDD VDD _04364_ sky130_fd_sc_hd__inv_1
X_08976_ _04364_ _02516_ _02520_ VSS VSS VDD VDD _04365_ sky130_fd_sc_hd__nor3_1
X_08977_ _04362_ _04358_ _04365_ VSS VSS VDD VDD _04366_ sky130_fd_sc_hd__o21ai_0
X_08978_ _02525_ _02521_ VSS VSS VDD VDD _04367_ sky130_fd_sc_hd__nor2b_1
X_08979_ _04358_ _04367_ _02517_ VSS VSS VDD VDD _04368_ sky130_fd_sc_hd__nand3b_1
X_08980_ _02521_ _04364_ _02520_ VSS VSS VDD VDD _04369_ sky130_fd_sc_hd__nor3_1
X_08981_ _04364_ _02520_ _04367_ _02516_ _04369_ VSS VSS VDD
+ VDD _04370_ sky130_fd_sc_hd__a221oi_1
X_08982_ _04366_ _04368_ _04370_ VSS VSS VDD VDD stage3_out\[126\]
+ sky130_fd_sc_hd__nand3_1
X_08983_ _04361_ _02521_ VSS VSS VDD VDD _04371_ sky130_fd_sc_hd__nand2b_1
X_08984_ _04364_ _02520_ _02524_ VSS VSS VDD VDD _04372_ sky130_fd_sc_hd__nor3_1
X_08985_ _04364_ _02524_ _04371_ _04372_ VSS VSS VDD VDD stage3_out\[127\]
+ sky130_fd_sc_hd__a22o_1
X_08986_ _01087_ _02473_ VSS VSS VDD VDD stage3_out\[113\]
+ sky130_fd_sc_hd__xnor2_1
X_08987_ _02477_ _04341_ VSS VSS VDD VDD stage3_out\[114\]
+ sky130_fd_sc_hd__xnor2_1
X_08988_ _04323_ _04320_ _04322_ VSS VSS VDD VDD _04373_ sky130_fd_sc_hd__and3_1
X_08989_ _04324_ _04373_ VSS VSS VDD VDD stage3_out\[115\]
+ sky130_fd_sc_hd__nor2_1
X_08990_ _02485_ _04343_ VSS VSS VDD VDD stage3_out\[116\]
+ sky130_fd_sc_hd__xnor2_1
X_08991_ _04326_ _04319_ _04325_ VSS VSS VDD VDD _04374_ sky130_fd_sc_hd__and3_1
X_08992_ _04327_ _04374_ VSS VSS VDD VDD stage3_out\[117\]
+ sky130_fd_sc_hd__nor2_1
X_08993_ _02493_ _04345_ VSS VSS VDD VDD stage3_out\[118\]
+ sky130_fd_sc_hd__xnor2_1
X_08994_ _04329_ _04318_ _04328_ VSS VSS VDD VDD _04375_ sky130_fd_sc_hd__and3_1
X_08995_ _04330_ _04375_ VSS VSS VDD VDD stage3_out\[119\]
+ sky130_fd_sc_hd__nor2_1
X_08996_ _02501_ _04347_ VSS VSS VDD VDD stage3_out\[120\]
+ sky130_fd_sc_hd__xnor2_1
X_08997_ _02473_ _01091_ _02474_ VSS VSS VDD VDD _04376_ sky130_fd_sc_hd__o21bai_1
X_08998_ _04338_ _04376_ _02478_ VSS VSS VDD VDD _04377_ sky130_fd_sc_hd__a21o_1
X_08999_ _04323_ _04377_ _02482_ VSS VSS VDD VDD _04378_ sky130_fd_sc_hd__a21oi_1
X_09000_ _02485_ _04378_ _02486_ VSS VSS VDD VDD _04379_ sky130_fd_sc_hd__o21bai_1
X_09001_ _04326_ _04379_ _02490_ VSS VSS VDD VDD _04380_ sky130_fd_sc_hd__a21oi_1
X_09002_ _02493_ _04380_ _02494_ VSS VSS VDD VDD _04381_ sky130_fd_sc_hd__o21bai_1
X_09003_ _04329_ _04381_ _02498_ VSS VSS VDD VDD _04382_ sky130_fd_sc_hd__a21oi_1
X_09004_ _02501_ _04382_ _02502_ VSS VSS VDD VDD _04383_ sky130_fd_sc_hd__o21bai_1
X_09005_ _02505_ _04383_ VSS VSS VDD VDD stage3_out\[249\]
+ sky130_fd_sc_hd__xnor2_1
X_09006_ _02473_ VSS VSS VDD VDD _04384_ sky130_fd_sc_hd__inv_1
X_09007_ _02469_ _01090_ _02470_ VSS VSS VDD VDD _04385_ sky130_fd_sc_hd__o21bai_1
X_09008_ _04384_ _04385_ _02474_ VSS VSS VDD VDD _04386_ sky130_fd_sc_hd__a21oi_1
X_09009_ _02477_ _04386_ _02478_ VSS VSS VDD VDD _04387_ sky130_fd_sc_hd__o21bai_1
X_09010_ _04323_ _04387_ _02482_ VSS VSS VDD VDD _04388_ sky130_fd_sc_hd__a21oi_1
X_09011_ _02485_ _04388_ _02486_ VSS VSS VDD VDD _04389_ sky130_fd_sc_hd__o21bai_1
X_09012_ _04326_ _04389_ _02490_ VSS VSS VDD VDD _04390_ sky130_fd_sc_hd__a21oi_1
X_09013_ _02493_ _04390_ _02494_ VSS VSS VDD VDD _04391_ sky130_fd_sc_hd__o21bai_1
X_09014_ _04329_ _04391_ _02498_ VSS VSS VDD VDD _04392_ sky130_fd_sc_hd__a21oi_1
X_09015_ _02501_ _04392_ _02502_ VSS VSS VDD VDD _04393_ sky130_fd_sc_hd__o21bai_1
X_09016_ _04332_ _04393_ _02506_ VSS VSS VDD VDD _04394_ sky130_fd_sc_hd__a21oi_1
X_09017_ _04356_ _04394_ VSS VSS VDD VDD stage3_out\[250\]
+ sky130_fd_sc_hd__xnor2_1
X_09018_ _04332_ _04383_ _02506_ VSS VSS VDD VDD _04395_ sky130_fd_sc_hd__a21oi_1
X_09019_ _02509_ _04395_ _02510_ VSS VSS VDD VDD _04396_ sky130_fd_sc_hd__o21bai_1
X_09020_ _02513_ _04396_ VSS VSS VDD VDD stage3_out\[251\]
+ sky130_fd_sc_hd__xnor2_1
X_09021_ _02509_ _04394_ _02510_ VSS VSS VDD VDD _04397_ sky130_fd_sc_hd__o21bai_1
X_09022_ _04352_ _04397_ _02514_ VSS VSS VDD VDD _04398_ sky130_fd_sc_hd__a21oi_1
X_09023_ _04362_ _04398_ VSS VSS VDD VDD stage3_out\[252\]
+ sky130_fd_sc_hd__xnor2_1
X_09024_ _04352_ _04396_ _02514_ VSS VSS VDD VDD _04399_ sky130_fd_sc_hd__a21oi_1
X_09025_ _02517_ _04399_ VSS VSS VDD VDD _04400_ sky130_fd_sc_hd__nor2_1
X_09026_ _02518_ _04400_ VSS VSS VDD VDD _04401_ sky130_fd_sc_hd__nor2_1
X_09027_ _02521_ _04401_ VSS VSS VDD VDD stage3_out\[253\]
+ sky130_fd_sc_hd__xor2_1
X_09028_ _02518_ _02522_ VSS VSS VDD VDD _04402_ sky130_fd_sc_hd__nor2_1
X_09029_ _02517_ _04398_ _04402_ _02525_ VSS VSS VDD VDD _04403_
+ sky130_fd_sc_hd__o211a_1
X_09030_ _02517_ _02521_ _02525_ _04398_ VSS VSS VDD VDD _04404_
+ sky130_fd_sc_hd__nor4_1
X_09031_ _02522_ VSS VSS VDD VDD _04405_ sky130_fd_sc_hd__inv_1
X_09032_ _02521_ _02525_ _02518_ VSS VSS VDD VDD _04406_ sky130_fd_sc_hd__nor3b_1
X_09033_ _02521_ _04405_ _02525_ _04406_ VSS VSS VDD VDD _04407_
+ sky130_fd_sc_hd__a31oi_1
X_09034_ _04405_ _02525_ _04407_ VSS VSS VDD VDD _04408_ sky130_fd_sc_hd__o21ai_0
X_09035_ _04403_ _04404_ _04408_ VSS VSS VDD VDD stage3_out\[254\]
+ sky130_fd_sc_hd__nor3_1
X_09036_ _02522_ _02525_ _02526_ VSS VSS VDD VDD _04409_ sky130_fd_sc_hd__nor3_1
X_09037_ _02521_ _04401_ _04409_ VSS VSS VDD VDD _04410_ sky130_fd_sc_hd__o21ai_0
X_09038_ _02525_ _02526_ VSS VSS VDD VDD _04411_ sky130_fd_sc_hd__nand2_1
X_09039_ _04410_ _04411_ VSS VSS VDD VDD stage3_out\[255\]
+ sky130_fd_sc_hd__nand2_1
X_09040_ _02473_ _01091_ VSS VSS VDD VDD stage3_out\[241\]
+ sky130_fd_sc_hd__xor2_1
X_09041_ _04338_ _04386_ VSS VSS VDD VDD stage3_out\[242\]
+ sky130_fd_sc_hd__xnor2_1
X_09042_ _02481_ _04377_ VSS VSS VDD VDD stage3_out\[243\]
+ sky130_fd_sc_hd__xnor2_1
X_09043_ _04337_ _04388_ VSS VSS VDD VDD stage3_out\[244\]
+ sky130_fd_sc_hd__xnor2_1
X_09044_ _02489_ _04379_ VSS VSS VDD VDD stage3_out\[245\]
+ sky130_fd_sc_hd__xnor2_1
X_09045_ _04336_ _04390_ VSS VSS VDD VDD stage3_out\[246\]
+ sky130_fd_sc_hd__xnor2_1
X_09046_ _02497_ _04381_ VSS VSS VDD VDD stage3_out\[247\]
+ sky130_fd_sc_hd__xnor2_1
X_09047_ _04335_ _04392_ VSS VSS VDD VDD stage3_out\[248\]
+ sky130_fd_sc_hd__xnor2_1
X_09048_ _01933_ VSS VSS VDD VDD _04412_ sky130_fd_sc_hd__inv_1
Xinput110 in_flat[54] VSS VSS VDD VDD net109 sky130_fd_sc_hd__clkdlybuf4s50_1
X_09050_ _01912_ VSS VSS VDD VDD _04414_ sky130_fd_sc_hd__inv_1
X_09051_ _01984_ VSS VSS VDD VDD _04415_ sky130_fd_sc_hd__inv_1
X_09052_ net412 VSS VSS VDD VDD _04416_ sky130_fd_sc_hd__inv_1
X_09053_ _01974_ _01096_ _01976_ VSS VSS VDD VDD _04417_ sky130_fd_sc_hd__o21bai_1
X_09054_ _04416_ _04417_ _01981_ VSS VSS VDD VDD _04418_ sky130_fd_sc_hd__a21o_1
X_09055_ _04415_ _04418_ _01986_ VSS VSS VDD VDD _04419_ sky130_fd_sc_hd__a21oi_1
X_09056_ _04419_ _01904_ _01906_ VSS VSS VDD VDD _04420_ sky130_fd_sc_hd__o21bai_1
X_09057_ _04414_ _04420_ _01914_ VSS VSS VDD VDD _04421_ sky130_fd_sc_hd__a21oi_1
X_09058_ _01922_ _04421_ _01924_ VSS VSS VDD VDD _04422_ sky130_fd_sc_hd__o21bai_1
X_09059_ _04412_ _04422_ _01935_ VSS VSS VDD VDD _04423_ sky130_fd_sc_hd__a21oi_1
X_09060_ _01989_ _04423_ _01991_ VSS VSS VDD VDD _04424_ sky130_fd_sc_hd__o21bai_1
X_09061_ _01994_ _04424_ VSS VSS VDD VDD stage3_out\[73\]
+ sky130_fd_sc_hd__xnor2_1
Xinput109 in_flat[53] VSS VSS VDD VDD net108 sky130_fd_sc_hd__clkdlybuf4s50_1
X_09063_ _01976_ VSS VSS VDD VDD _04426_ sky130_fd_sc_hd__inv_1
X_09064_ _03310_ _03311_ _03312_ _01970_ VSS VSS VDD VDD _04427_
+ sky130_fd_sc_hd__a31oi_1
X_09065_ _01974_ VSS VSS VDD VDD _04428_ sky130_fd_sc_hd__inv_1
X_09066_ _01971_ _04427_ _04428_ VSS VSS VDD VDD _04429_ sky130_fd_sc_hd__o21ai_0
X_09067_ _04426_ _04429_ net412 VSS VSS VDD VDD _04430_ sky130_fd_sc_hd__a21oi_1
X_09068_ _01906_ _01981_ _01986_ VSS VSS VDD VDD _04431_ sky130_fd_sc_hd__or3_1
X_09069_ _04415_ _01986_ VSS VSS VDD VDD _04432_ sky130_fd_sc_hd__nor2_1
X_09070_ _01904_ _04432_ _01906_ VSS VSS VDD VDD _04433_ sky130_fd_sc_hd__o21bai_1
X_09071_ _01912_ _01922_ _01933_ VSS VSS VDD VDD _04434_ sky130_fd_sc_hd__nor3_1
X_09072_ _04430_ _04431_ _04433_ _04434_ VSS VSS VDD VDD _04435_
+ sky130_fd_sc_hd__o211ai_1
X_09073_ _01922_ _01933_ VSS VSS VDD VDD _04436_ sky130_fd_sc_hd__nor2_1
X_09074_ _04412_ _01924_ _04436_ _01914_ VSS VSS VDD VDD _04437_
+ sky130_fd_sc_hd__a22oi_1
X_09075_ _01935_ _01991_ _01996_ VSS VSS VDD VDD _04438_ sky130_fd_sc_hd__nor3_1
X_09076_ _01994_ VSS VSS VDD VDD _04439_ sky130_fd_sc_hd__inv_1
X_09077_ _01991_ _01989_ VSS VSS VDD VDD _04440_ sky130_fd_sc_hd__nand2b_1
X_09078_ _04439_ _04440_ _01996_ VSS VSS VDD VDD _04441_ sky130_fd_sc_hd__a21oi_1
X_09079_ _04435_ _04437_ _04438_ _04441_ VSS VSS VDD VDD _04442_
+ sky130_fd_sc_hd__a31oi_1
X_09080_ _01999_ _04442_ VSS VSS VDD VDD stage3_out\[74\]
+ sky130_fd_sc_hd__xnor2_1
X_09081_ _04439_ _04424_ _01996_ VSS VSS VDD VDD _04443_ sky130_fd_sc_hd__a21oi_1
X_09082_ _04443_ _01999_ _02001_ VSS VSS VDD VDD _04444_ sky130_fd_sc_hd__o21bai_1
X_09083_ _02004_ net469 VSS VSS VDD VDD stage3_out\[75\] sky130_fd_sc_hd__xnor2_1
Xinput108 in_flat[52] VSS VSS VDD VDD net107 sky130_fd_sc_hd__clkdlybuf4s50_1
X_09085_ _02004_ VSS VSS VDD VDD _04446_ sky130_fd_sc_hd__inv_1
X_09086_ _01999_ _02004_ VSS VSS VDD VDD _04447_ sky130_fd_sc_hd__nor2_1
X_09087_ _04446_ _02001_ _04442_ _04447_ _02006_ VSS VSS VDD
+ VDD _04448_ sky130_fd_sc_hd__a221o_1
X_09088_ _02009_ _04448_ VSS VSS VDD VDD stage3_out\[76\]
+ sky130_fd_sc_hd__xnor2_1
X_09089_ _04446_ _04444_ _02006_ VSS VSS VDD VDD _04449_ sky130_fd_sc_hd__a21oi_1
X_09090_ _02009_ _04449_ VSS VSS VDD VDD _04450_ sky130_fd_sc_hd__nor2_1
X_09091_ _02011_ _04450_ VSS VSS VDD VDD _04451_ sky130_fd_sc_hd__nor2_1
X_09092_ _02014_ _04451_ VSS VSS VDD VDD stage3_out\[77\]
+ sky130_fd_sc_hd__xor2_1
X_09093_ _02009_ VSS VSS VDD VDD _04452_ sky130_fd_sc_hd__inv_1
X_09094_ _04452_ _04448_ _02011_ VSS VSS VDD VDD _04453_ sky130_fd_sc_hd__a21oi_1
X_09095_ _02014_ _04453_ _02016_ VSS VSS VDD VDD _04454_ sky130_fd_sc_hd__o21bai_1
X_09096_ _01968_ _04454_ VSS VSS VDD VDD stage3_out\[78\]
+ sky130_fd_sc_hd__xnor2_1
X_09097_ _01968_ _02016_ _02019_ VSS VSS VDD VDD _04455_ sky130_fd_sc_hd__nor3_1
X_09098_ _02014_ _04451_ _04455_ VSS VSS VDD VDD _04456_ sky130_fd_sc_hd__o21ai_0
X_09099_ _01968_ _02019_ VSS VSS VDD VDD _04457_ sky130_fd_sc_hd__nand2_1
X_09100_ _04456_ _04457_ VSS VSS VDD VDD stage3_out\[79\]
+ sky130_fd_sc_hd__nand2_1
X_09101_ _01974_ _01096_ VSS VSS VDD VDD stage3_out\[65\]
+ sky130_fd_sc_hd__xor2_1
X_09102_ _04426_ _04429_ VSS VSS VDD VDD _04458_ sky130_fd_sc_hd__nand2_1
X_09103_ net412 _04458_ VSS VSS VDD VDD stage3_out\[66\] sky130_fd_sc_hd__xnor2_1
X_09104_ _01984_ _04418_ VSS VSS VDD VDD stage3_out\[67\]
+ sky130_fd_sc_hd__xnor2_1
X_09105_ _01981_ _04430_ VSS VSS VDD VDD _04459_ sky130_fd_sc_hd__nor2_1
X_09106_ _01984_ _04459_ VSS VSS VDD VDD _04460_ sky130_fd_sc_hd__nor2_1
X_09107_ _01986_ _04460_ VSS VSS VDD VDD _04461_ sky130_fd_sc_hd__nor2_1
X_09108_ _01904_ _04461_ VSS VSS VDD VDD stage3_out\[68\]
+ sky130_fd_sc_hd__xor2_1
X_09109_ _01912_ net470 VSS VSS VDD VDD stage3_out\[69\] sky130_fd_sc_hd__xnor2_1
X_09110_ _04430_ _04431_ _04433_ VSS VSS VDD VDD _04462_ sky130_fd_sc_hd__o21ai_0
X_09111_ _01912_ _04462_ _01914_ VSS VSS VDD VDD _04463_ sky130_fd_sc_hd__o21bai_1
X_09112_ _01922_ _04463_ VSS VSS VDD VDD stage3_out\[70\]
+ sky130_fd_sc_hd__xnor2_1
X_09113_ _01933_ _04422_ VSS VSS VDD VDD stage3_out\[71\]
+ sky130_fd_sc_hd__xnor2_1
X_09114_ _01935_ _04435_ _04437_ VSS VSS VDD VDD _04464_ sky130_fd_sc_hd__nand3b_1
X_09115_ _01989_ _04464_ VSS VSS VDD VDD stage3_out\[72\]
+ sky130_fd_sc_hd__xnor2_1
X_09116_ _02311_ VSS VSS VDD VDD _04465_ sky130_fd_sc_hd__inv_1
X_09117_ _02269_ VSS VSS VDD VDD _04466_ sky130_fd_sc_hd__inv_1
Xinput107 in_flat[51] VSS VSS VDD VDD net106 sky130_fd_sc_hd__clkdlybuf4s50_1
X_09119_ _02432_ VSS VSS VDD VDD _04468_ sky130_fd_sc_hd__inv_1
Xinput106 in_flat[50] VSS VSS VDD VDD net105 sky130_fd_sc_hd__clkdlybuf4s50_1
Xinput105 in_flat[4] VSS VSS VDD VDD net104 sky130_fd_sc_hd__clkdlybuf4s50_1
X_09122_ _02422_ _01101_ _02424_ VSS VSS VDD VDD _04471_ sky130_fd_sc_hd__o21ba_2
X_09123_ _02429_ VSS VSS VDD VDD _04472_ sky130_fd_sc_hd__inv_1
X_09124_ _02427_ _04471_ _04472_ VSS VSS VDD VDD _04473_ sky130_fd_sc_hd__o21ai_0
X_09125_ _04468_ _04473_ _02434_ VSS VSS VDD VDD _04474_ sky130_fd_sc_hd__a21oi_1
X_09126_ _02247_ VSS VSS VDD VDD _04475_ sky130_fd_sc_hd__inv_1
X_09127_ _02245_ _04474_ _04475_ VSS VSS VDD VDD _04476_ sky130_fd_sc_hd__o21ai_0
X_09128_ _04466_ _04476_ _02271_ VSS VSS VDD VDD _04477_ sky130_fd_sc_hd__a21oi_1
X_09129_ _02291_ _04477_ _02293_ VSS VSS VDD VDD _04478_ sky130_fd_sc_hd__o21bai_1
X_09130_ _04465_ _04478_ _02313_ VSS VSS VDD VDD _04479_ sky130_fd_sc_hd__a21oi_1
X_09131_ _02437_ _04479_ _02439_ VSS VSS VDD VDD _04480_ sky130_fd_sc_hd__o21bai_1
X_09132_ _02442_ _04480_ VSS VSS VDD VDD stage3_out\[89\]
+ sky130_fd_sc_hd__xnor2_1
Xinput104 in_flat[49] VSS VSS VDD VDD net103 sky130_fd_sc_hd__clkdlybuf4s50_1
X_09134_ _02422_ _02418_ _02427_ VSS VSS VDD VDD _04482_ sky130_fd_sc_hd__or3_1
X_09135_ _02422_ _02427_ VSS VSS VDD VDD _04483_ sky130_fd_sc_hd__nor2_1
X_09136_ _02427_ _02424_ VSS VSS VDD VDD _04484_ sky130_fd_sc_hd__nor2b_1
X_09137_ _02419_ _04483_ _04484_ VSS VSS VDD VDD _04485_ sky130_fd_sc_hd__a21oi_1
X_09138_ _02434_ VSS VSS VDD VDD _04486_ sky130_fd_sc_hd__inv_1
X_09139_ _04466_ _02247_ _02271_ VSS VSS VDD VDD _04487_ sky130_fd_sc_hd__a21oi_1
X_09140_ _04472_ _04486_ _04487_ VSS VSS VDD VDD _04488_ sky130_fd_sc_hd__and3_1
X_09141_ _01099_ _04482_ _04485_ _04488_ VSS VSS VDD VDD _04489_
+ sky130_fd_sc_hd__o211ai_1
X_09142_ _02245_ _04475_ _02269_ VSS VSS VDD VDD _04490_ sky130_fd_sc_hd__a21oi_1
X_09143_ _02291_ _02311_ VSS VSS VDD VDD _04491_ sky130_fd_sc_hd__nor2_1
X_09144_ _02271_ _04490_ _04491_ VSS VSS VDD VDD _04492_ sky130_fd_sc_hd__o21ai_0
X_09145_ _02432_ _04486_ _04487_ _04492_ VSS VSS VDD VDD _04493_
+ sky130_fd_sc_hd__a31oi_1
X_09146_ _04465_ _02293_ _02313_ VSS VSS VDD VDD _04494_ sky130_fd_sc_hd__a21o_1
X_09147_ _04489_ _04493_ _04494_ _02444_ _02439_ VSS VSS VDD
+ VDD _04495_ sky130_fd_sc_hd__a2111o_1
X_09148_ _02442_ VSS VSS VDD VDD _04496_ sky130_fd_sc_hd__inv_1
X_09149_ _02439_ _02437_ VSS VSS VDD VDD _04497_ sky130_fd_sc_hd__nand2b_1
X_09150_ _04496_ _04497_ _02444_ VSS VSS VDD VDD _04498_ sky130_fd_sc_hd__a21o_1
X_09151_ _04495_ _04498_ VSS VSS VDD VDD _04499_ sky130_fd_sc_hd__nand2_1
X_09152_ _02447_ _04499_ VSS VSS VDD VDD stage3_out\[90\]
+ sky130_fd_sc_hd__xor2_1
X_09153_ _04496_ _04480_ _02444_ VSS VSS VDD VDD _04500_ sky130_fd_sc_hd__a21oi_1
X_09154_ _02447_ _04500_ _02449_ VSS VSS VDD VDD _04501_ sky130_fd_sc_hd__o21bai_1
X_09155_ _02452_ _04501_ VSS VSS VDD VDD stage3_out\[91\]
+ sky130_fd_sc_hd__xnor2_1
X_09156_ _02447_ _02452_ VSS VSS VDD VDD _04502_ sky130_fd_sc_hd__nor2_1
X_09157_ _02452_ VSS VSS VDD VDD _04503_ sky130_fd_sc_hd__inv_1
X_09158_ _04503_ _02449_ _02454_ VSS VSS VDD VDD _04504_ sky130_fd_sc_hd__a21o_1
X_09159_ _04495_ _04498_ _04502_ _04504_ VSS VSS VDD VDD _04505_
+ sky130_fd_sc_hd__a31oi_1
X_09160_ _02457_ _04505_ VSS VSS VDD VDD stage3_out\[92\]
+ sky130_fd_sc_hd__xor2_1
Xinput103 in_flat[48] VSS VSS VDD VDD net102 sky130_fd_sc_hd__clkdlybuf4s50_1
X_09162_ _04503_ _04501_ _02454_ VSS VSS VDD VDD _04507_ sky130_fd_sc_hd__a21oi_1
X_09163_ _02457_ _04507_ VSS VSS VDD VDD _04508_ sky130_fd_sc_hd__nor2_1
X_09164_ _02459_ _04508_ VSS VSS VDD VDD _04509_ sky130_fd_sc_hd__nor2_1
X_09165_ _02462_ _04509_ VSS VSS VDD VDD stage3_out\[93\]
+ sky130_fd_sc_hd__xor2_1
X_09166_ _02457_ _02462_ _04505_ _02416_ VSS VSS VDD VDD _04510_
+ sky130_fd_sc_hd__or4b_2
X_09167_ _02416_ _02459_ _02464_ VSS VSS VDD VDD _04511_ sky130_fd_sc_hd__nor3_1
X_09168_ _04505_ _04511_ VSS VSS VDD VDD _04512_ sky130_fd_sc_hd__nand2_1
X_09169_ _02416_ _02459_ _02464_ _02457_ VSS VSS VDD VDD _04513_
+ sky130_fd_sc_hd__nor4b_1
X_09170_ _02416_ _02464_ _02462_ VSS VSS VDD VDD _04514_ sky130_fd_sc_hd__nor3b_1
X_09171_ _02462_ _02416_ _02459_ VSS VSS VDD VDD _04515_ sky130_fd_sc_hd__and3b_1
X_09172_ _02416_ _02464_ _04513_ _04514_ _04515_ VSS VSS VDD
+ VDD _04516_ sky130_fd_sc_hd__a2111oi_0
X_09173_ _04510_ _04512_ _04516_ VSS VSS VDD VDD stage3_out\[94\]
+ sky130_fd_sc_hd__nand3_1
X_09174_ _02416_ _02464_ _02467_ VSS VSS VDD VDD _04517_ sky130_fd_sc_hd__nor3_1
X_09175_ _02462_ _04509_ _04517_ VSS VSS VDD VDD _04518_ sky130_fd_sc_hd__o21ai_0
X_09176_ _02416_ _02467_ VSS VSS VDD VDD _04519_ sky130_fd_sc_hd__nand2_1
X_09177_ _04518_ _04519_ VSS VSS VDD VDD stage3_out\[95\]
+ sky130_fd_sc_hd__nand2_1
X_09178_ _02422_ _01101_ VSS VSS VDD VDD stage3_out\[81\]
+ sky130_fd_sc_hd__xor2_1
X_09179_ _02422_ VSS VSS VDD VDD _04520_ sky130_fd_sc_hd__inv_1
X_09180_ _02418_ _01099_ _02419_ VSS VSS VDD VDD _04521_ sky130_fd_sc_hd__o21bai_1
X_09181_ _04520_ _04521_ _02424_ VSS VSS VDD VDD _04522_ sky130_fd_sc_hd__a21oi_1
X_09182_ _02427_ _04522_ VSS VSS VDD VDD stage3_out\[82\]
+ sky130_fd_sc_hd__xor2_1
X_09183_ _02432_ _04473_ VSS VSS VDD VDD stage3_out\[83\]
+ sky130_fd_sc_hd__xnor2_1
X_09184_ _01099_ _04482_ _04485_ _04472_ VSS VSS VDD VDD _04523_
+ sky130_fd_sc_hd__o211ai_1
X_09185_ _04468_ _04523_ _02434_ VSS VSS VDD VDD _04524_ sky130_fd_sc_hd__a21oi_1
X_09186_ _02245_ _04524_ VSS VSS VDD VDD stage3_out\[84\]
+ sky130_fd_sc_hd__xor2_1
X_09187_ _02269_ _04476_ VSS VSS VDD VDD stage3_out\[85\]
+ sky130_fd_sc_hd__xnor2_1
X_09188_ _02245_ _04524_ _04475_ VSS VSS VDD VDD _04525_ sky130_fd_sc_hd__o21ai_0
X_09189_ _04466_ _04525_ _02271_ VSS VSS VDD VDD _04526_ sky130_fd_sc_hd__a21oi_1
X_09190_ _02291_ _04526_ VSS VSS VDD VDD stage3_out\[86\]
+ sky130_fd_sc_hd__xor2_1
X_09191_ _02311_ _04478_ VSS VSS VDD VDD stage3_out\[87\]
+ sky130_fd_sc_hd__xnor2_1
X_09192_ _02437_ VSS VSS VDD VDD _04527_ sky130_fd_sc_hd__inv_1
X_09193_ _04489_ _04493_ _04494_ VSS VSS VDD VDD _04528_ sky130_fd_sc_hd__a21oi_1
X_09194_ _04527_ _04528_ VSS VSS VDD VDD stage3_out\[88\]
+ sky130_fd_sc_hd__xnor2_1
X_09195_ _01988_ VSS VSS VDD VDD _04529_ sky130_fd_sc_hd__inv_1
X_09196_ _01921_ VSS VSS VDD VDD _04530_ sky130_fd_sc_hd__inv_1
X_09197_ _01903_ VSS VSS VDD VDD _04531_ sky130_fd_sc_hd__inv_1
X_09198_ _01978_ VSS VSS VDD VDD _04532_ sky130_fd_sc_hd__inv_1
X_09199_ _01105_ _01974_ VSS VSS VDD VDD _04533_ sky130_fd_sc_hd__nor2b_1
X_09200_ _01973_ _04533_ _01979_ VSS VSS VDD VDD _04534_ sky130_fd_sc_hd__o21ai_0
X_09201_ _04532_ _04534_ _04415_ VSS VSS VDD VDD _04535_ sky130_fd_sc_hd__a21oi_1
X_09202_ _01983_ _04535_ _01904_ VSS VSS VDD VDD _04536_ sky130_fd_sc_hd__o21ai_0
X_09203_ _04531_ _04536_ _04414_ VSS VSS VDD VDD _04537_ sky130_fd_sc_hd__a21oi_1
X_09204_ _01911_ _04537_ _01922_ VSS VSS VDD VDD _04538_ sky130_fd_sc_hd__o21ai_1
X_09205_ _04538_ _04530_ _04412_ VSS VSS VDD VDD _04539_ sky130_fd_sc_hd__a21oi_1
X_09206_ _01932_ _04539_ _01989_ VSS VSS VDD VDD _04540_ sky130_fd_sc_hd__o21ai_1
X_09207_ _04529_ _04540_ _04439_ VSS VSS VDD VDD _04541_ sky130_fd_sc_hd__a21oi_1
X_09208_ _04439_ _04529_ _04540_ VSS VSS VDD VDD _04542_ sky130_fd_sc_hd__and3_1
X_09209_ _04541_ _04542_ VSS VSS VDD VDD stage3_out\[201\]
+ sky130_fd_sc_hd__nor2_1
X_09210_ stage3_in_r\[192\] _01970_ _03311_ _03312_ _01969_
+ VSS VSS VDD VDD _04543_ sky130_fd_sc_hd__a41oi_1
X_09211_ _04428_ _04543_ _01973_ VSS VSS VDD VDD _04544_ sky130_fd_sc_hd__o21bai_1
X_09212_ net412 _04544_ _01903_ _01983_ _01978_ VSS VSS VDD
+ VDD _04545_ sky130_fd_sc_hd__a2111oi_0
X_09213_ _01984_ _01983_ _01904_ VSS VSS VDD VDD _04546_ sky130_fd_sc_hd__o21a_1
X_09214_ _01903_ _04546_ VSS VSS VDD VDD _04547_ sky130_fd_sc_hd__nor2_1
X_09215_ _01912_ _01922_ _01933_ VSS VSS VDD VDD _04548_ sky130_fd_sc_hd__nand3_1
X_09216_ _01911_ _01922_ VSS VSS VDD VDD _04549_ sky130_fd_sc_hd__and2_1
X_09217_ _01921_ _04549_ _01933_ VSS VSS VDD VDD _04550_ sky130_fd_sc_hd__o21ai_0
X_09218_ _04545_ _04547_ _04548_ _04550_ VSS VSS VDD VDD _04551_
+ sky130_fd_sc_hd__o31ai_1
X_09219_ _01989_ _01988_ VSS VSS VDD VDD _04552_ sky130_fd_sc_hd__nor2_1
X_09220_ _04439_ _04552_ _01993_ VSS VSS VDD VDD _04553_ sky130_fd_sc_hd__o21bai_1
X_09221_ _01932_ _01988_ _01993_ _04551_ _04553_ VSS VSS VDD
+ VDD _04554_ sky130_fd_sc_hd__o41a_1
X_09222_ _01999_ _04554_ VSS VSS VDD VDD stage3_out\[202\]
+ sky130_fd_sc_hd__xor2_1
X_09223_ _01998_ VSS VSS VDD VDD _04555_ sky130_fd_sc_hd__inv_1
X_09224_ _01993_ _04541_ _01999_ VSS VSS VDD VDD _04556_ sky130_fd_sc_hd__o21ai_0
X_09225_ _04556_ _04555_ _04446_ VSS VSS VDD VDD _04557_ sky130_fd_sc_hd__a21oi_1
X_09226_ _04446_ _04555_ _04556_ VSS VSS VDD VDD _04558_ sky130_fd_sc_hd__and3_1
X_09227_ _04557_ _04558_ VSS VSS VDD VDD stage3_out\[203\]
+ sky130_fd_sc_hd__nor2_1
X_09228_ _01999_ _04554_ _01998_ VSS VSS VDD VDD _04559_ sky130_fd_sc_hd__a21oi_1
X_09229_ _04446_ _04559_ VSS VSS VDD VDD _04560_ sky130_fd_sc_hd__nor2_1
X_09230_ _02003_ _04560_ VSS VSS VDD VDD _04561_ sky130_fd_sc_hd__nor2_1
X_09231_ _02009_ _04561_ VSS VSS VDD VDD stage3_out\[204\]
+ sky130_fd_sc_hd__xnor2_1
X_09232_ _02003_ _04557_ _02009_ VSS VSS VDD VDD _04562_ sky130_fd_sc_hd__o21a_1
X_09233_ _02008_ _04562_ VSS VSS VDD VDD _04563_ sky130_fd_sc_hd__nor2_1
X_09234_ _02014_ _04563_ VSS VSS VDD VDD stage3_out\[205\]
+ sky130_fd_sc_hd__xnor2_1
X_09235_ _01999_ _02004_ _02009_ _04554_ VSS VSS VDD VDD _04564_
+ sky130_fd_sc_hd__nand4_1
X_09236_ _02009_ _02003_ VSS VSS VDD VDD _04565_ sky130_fd_sc_hd__nand2_1
X_09237_ _02004_ _02009_ _01998_ VSS VSS VDD VDD _04566_ sky130_fd_sc_hd__nand3_1
X_09238_ _02008_ _04564_ _04565_ _04566_ VSS VSS VDD VDD _04567_
+ sky130_fd_sc_hd__nand4b_1
X_09239_ _02014_ _04567_ _02013_ VSS VSS VDD VDD _04568_ sky130_fd_sc_hd__a21oi_1
X_09240_ _02017_ _04568_ VSS VSS VDD VDD stage3_out\[206\]
+ sky130_fd_sc_hd__xnor2_1
X_09241_ _04563_ _02014_ VSS VSS VDD VDD _04569_ sky130_fd_sc_hd__nand2b_1
X_09242_ _02013_ _01967_ VSS VSS VDD VDD _04570_ sky130_fd_sc_hd__nor2_1
X_09243_ _02017_ _01967_ VSS VSS VDD VDD _04571_ sky130_fd_sc_hd__nor2b_1
X_09244_ _02017_ _04569_ _04570_ _04571_ VSS VSS VDD VDD stage3_out\[207\]
+ sky130_fd_sc_hd__a31o_2
X_09245_ _01974_ _01105_ VSS VSS VDD VDD stage3_out\[193\]
+ sky130_fd_sc_hd__xnor2_1
X_09246_ _04416_ _04544_ VSS VSS VDD VDD stage3_out\[194\]
+ sky130_fd_sc_hd__xnor2_1
X_09247_ _04415_ _04532_ _04534_ VSS VSS VDD VDD _04572_ sky130_fd_sc_hd__and3_1
X_09248_ _04535_ _04572_ VSS VSS VDD VDD stage3_out\[195\]
+ sky130_fd_sc_hd__nor2_1
X_09249_ net412 _04544_ _01978_ VSS VSS VDD VDD _04573_ sky130_fd_sc_hd__a21oi_1
X_09250_ _04415_ _04573_ VSS VSS VDD VDD _04574_ sky130_fd_sc_hd__nor2_1
X_09251_ _01983_ _04574_ VSS VSS VDD VDD _04575_ sky130_fd_sc_hd__nor2_1
X_09252_ _01904_ _04575_ VSS VSS VDD VDD stage3_out\[196\]
+ sky130_fd_sc_hd__xnor2_1
X_09253_ _04531_ _04414_ _04536_ VSS VSS VDD VDD _04576_ sky130_fd_sc_hd__and3_1
X_09254_ _04537_ _04576_ VSS VSS VDD VDD stage3_out\[197\]
+ sky130_fd_sc_hd__nor2_1
X_09255_ _04545_ _04547_ VSS VSS VDD VDD _04577_ sky130_fd_sc_hd__nor2_1
X_09256_ _01912_ _04577_ _01911_ VSS VSS VDD VDD _04578_ sky130_fd_sc_hd__a21oi_1
X_09257_ _01922_ _04578_ VSS VSS VDD VDD stage3_out\[198\]
+ sky130_fd_sc_hd__xnor2_1
X_09258_ _04530_ _04412_ _04538_ VSS VSS VDD VDD _04579_ sky130_fd_sc_hd__and3_1
X_09259_ _04539_ _04579_ VSS VSS VDD VDD stage3_out\[199\]
+ sky130_fd_sc_hd__nor2_1
X_09260_ _01932_ _04551_ VSS VSS VDD VDD _04580_ sky130_fd_sc_hd__nor2_1
X_09261_ _01989_ _04580_ VSS VSS VDD VDD stage3_out\[200\]
+ sky130_fd_sc_hd__xnor2_1
X_09262_ _02436_ VSS VSS VDD VDD _04581_ sky130_fd_sc_hd__inv_1
X_09263_ _02290_ VSS VSS VDD VDD _04582_ sky130_fd_sc_hd__inv_1
X_09264_ _02244_ VSS VSS VDD VDD _04583_ sky130_fd_sc_hd__inv_1
X_09265_ _02426_ VSS VSS VDD VDD _04584_ sky130_fd_sc_hd__inv_1
X_09266_ _01109_ _02422_ VSS VSS VDD VDD _04585_ sky130_fd_sc_hd__nor2b_1
X_09267_ _02421_ _04585_ _02427_ VSS VSS VDD VDD _04586_ sky130_fd_sc_hd__o21ai_0
X_09268_ _04584_ _04586_ _04468_ VSS VSS VDD VDD _04587_ sky130_fd_sc_hd__a21oi_1
X_09269_ _02431_ _04587_ _02245_ VSS VSS VDD VDD _04588_ sky130_fd_sc_hd__o21ai_1
X_09270_ _04583_ _04588_ _04466_ VSS VSS VDD VDD _04589_ sky130_fd_sc_hd__a21oi_1
X_09271_ _02268_ _04589_ _02291_ VSS VSS VDD VDD _04590_ sky130_fd_sc_hd__o21ai_0
X_09272_ _04582_ _04590_ _04465_ VSS VSS VDD VDD _04591_ sky130_fd_sc_hd__a21oi_1
X_09273_ _02310_ _04591_ _02437_ VSS VSS VDD VDD _04592_ sky130_fd_sc_hd__o21ai_0
X_09274_ _04581_ _04592_ _04496_ VSS VSS VDD VDD _04593_ sky130_fd_sc_hd__a21oi_1
X_09275_ _04496_ _04581_ _04592_ VSS VSS VDD VDD _04594_ sky130_fd_sc_hd__and3_1
X_09276_ _04593_ _04594_ VSS VSS VDD VDD stage3_out\[217\]
+ sky130_fd_sc_hd__nor2_1
X_09277_ _02125_ _02418_ net458 VSS VSS VDD VDD _04595_ sky130_fd_sc_hd__nand3b_1
X_09278_ _03478_ _03480_ _04595_ VSS VSS VDD VDD _04596_ sky130_fd_sc_hd__a21oi_1
X_09279_ net458 _02125_ _02418_ VSS VSS VDD VDD _04597_ sky130_fd_sc_hd__and3_1
X_09280_ _03478_ _03480_ _04597_ VSS VSS VDD VDD _04598_ sky130_fd_sc_hd__and3_1
X_09281_ _02417_ _02421_ _02426_ VSS VSS VDD VDD _04599_ sky130_fd_sc_hd__or3_1
X_09282_ _04596_ _04598_ _04599_ VSS VSS VDD VDD _04600_ sky130_fd_sc_hd__nor3_1
X_09283_ _02422_ _02421_ _02427_ VSS VSS VDD VDD _04601_ sky130_fd_sc_hd__o21ai_0
X_09284_ _04584_ _04601_ VSS VSS VDD VDD _04602_ sky130_fd_sc_hd__nand2_1
X_09285_ _02432_ _04602_ VSS VSS VDD VDD _04603_ sky130_fd_sc_hd__nand2_1
X_09286_ _04600_ _04603_ _02431_ VSS VSS VDD VDD _04604_ sky130_fd_sc_hd__o21bai_1
X_09287_ _02290_ _02311_ _02310_ VSS VSS VDD VDD _04605_ sky130_fd_sc_hd__a21oi_1
X_09288_ _02244_ _02269_ _02268_ VSS VSS VDD VDD _04606_ sky130_fd_sc_hd__a21oi_1
X_09289_ _04605_ _04606_ VSS VSS VDD VDD _04607_ sky130_fd_sc_hd__nand2_1
X_09290_ _02244_ _02245_ VSS VSS VDD VDD _04608_ sky130_fd_sc_hd__nor2_1
X_09291_ _04466_ _04608_ VSS VSS VDD VDD _04609_ sky130_fd_sc_hd__nor2_1
X_09292_ _02268_ _04609_ _02311_ _02291_ VSS VSS VDD VDD _04610_
+ sky130_fd_sc_hd__o211ai_1
X_09293_ _04605_ _04610_ VSS VSS VDD VDD _04611_ sky130_fd_sc_hd__nand2_1
X_09294_ _04604_ _04607_ _04611_ VSS VSS VDD VDD _04612_ sky130_fd_sc_hd__o21ai_0
X_09295_ _04527_ _04612_ _04581_ VSS VSS VDD VDD _04613_ sky130_fd_sc_hd__o21ai_0
X_09296_ _02442_ _04613_ _02441_ VSS VSS VDD VDD _04614_ sky130_fd_sc_hd__a21oi_1
X_09297_ _02447_ _04614_ VSS VSS VDD VDD stage3_out\[218\]
+ sky130_fd_sc_hd__xnor2_1
X_09298_ _02446_ VSS VSS VDD VDD _04615_ sky130_fd_sc_hd__inv_1
X_09299_ _02441_ _04593_ _02447_ VSS VSS VDD VDD _04616_ sky130_fd_sc_hd__o21ai_0
X_09300_ _04615_ _04616_ _04503_ VSS VSS VDD VDD _04617_ sky130_fd_sc_hd__a21oi_1
X_09301_ _04503_ _04615_ _04616_ VSS VSS VDD VDD _04618_ sky130_fd_sc_hd__and3_1
X_09302_ _04617_ _04618_ VSS VSS VDD VDD stage3_out\[219\]
+ sky130_fd_sc_hd__nor2_1
X_09303_ _02437_ _02442_ _02447_ VSS VSS VDD VDD _04619_ sky130_fd_sc_hd__and3_1
X_09304_ _04604_ _04607_ _04619_ _04611_ VSS VSS VDD VDD _04620_
+ sky130_fd_sc_hd__o211ai_1
X_09305_ _02442_ _02447_ _02436_ VSS VSS VDD VDD _04621_ sky130_fd_sc_hd__and3_1
X_09306_ _02447_ _02441_ _04621_ VSS VSS VDD VDD _04622_ sky130_fd_sc_hd__a21oi_1
X_09307_ _04615_ _04620_ _04622_ VSS VSS VDD VDD _04623_ sky130_fd_sc_hd__nand3_1
X_09308_ _02452_ _04623_ VSS VSS VDD VDD _04624_ sky130_fd_sc_hd__nand2_1
X_09309_ _02457_ _02451_ VSS VSS VDD VDD _04625_ sky130_fd_sc_hd__nor2_1
X_09310_ _02446_ _02451_ VSS VSS VDD VDD _04626_ sky130_fd_sc_hd__nor2_1
X_09311_ _02452_ _02451_ _02457_ VSS VSS VDD VDD _04627_ sky130_fd_sc_hd__o21ai_0
X_09312_ _04620_ _04622_ _04626_ _04627_ VSS VSS VDD VDD _04628_
+ sky130_fd_sc_hd__a31oi_1
X_09313_ _04624_ _04625_ _04628_ VSS VSS VDD VDD stage3_out\[220\]
+ sky130_fd_sc_hd__a21oi_1
X_09314_ _02451_ _04617_ _02457_ VSS VSS VDD VDD _04629_ sky130_fd_sc_hd__o21a_1
X_09315_ _02456_ _04629_ VSS VSS VDD VDD _04630_ sky130_fd_sc_hd__nor2_1
X_09316_ _02462_ _04630_ VSS VSS VDD VDD stage3_out\[221\]
+ sky130_fd_sc_hd__xnor2_1
X_09317_ _02465_ VSS VSS VDD VDD _04631_ sky130_fd_sc_hd__inv_1
X_09318_ _02456_ _02461_ _04631_ VSS VSS VDD VDD _04632_ sky130_fd_sc_hd__nor3_1
X_09319_ _02465_ _02462_ VSS VSS VDD VDD _04633_ sky130_fd_sc_hd__nor2b_1
X_09320_ _04632_ _04633_ _04628_ VSS VSS VDD VDD _04634_ sky130_fd_sc_hd__mux2i_1
X_09321_ _02462_ _02456_ _04631_ VSS VSS VDD VDD _04635_ sky130_fd_sc_hd__nand3_1
X_09322_ _02462_ _02461_ _04631_ _04635_ VSS VSS VDD VDD _04636_
+ sky130_fd_sc_hd__o31ai_1
X_09323_ _02461_ _04631_ _04636_ VSS VSS VDD VDD _04637_ sky130_fd_sc_hd__a21oi_1
X_09324_ _04634_ _04637_ VSS VSS VDD VDD stage3_out\[222\]
+ sky130_fd_sc_hd__nand2_1
X_09325_ _04630_ _02462_ VSS VSS VDD VDD _04638_ sky130_fd_sc_hd__nand2b_1
X_09326_ _02461_ _04631_ _02415_ VSS VSS VDD VDD _04639_ sky130_fd_sc_hd__nor3_1
X_09327_ _04631_ _02415_ _04638_ _04639_ VSS VSS VDD VDD stage3_out\[223\]
+ sky130_fd_sc_hd__a22o_1
X_09328_ _02422_ _01109_ VSS VSS VDD VDD stage3_out\[209\]
+ sky130_fd_sc_hd__xnor2_1
X_09329_ _02417_ _04596_ _04598_ VSS VSS VDD VDD _04640_ sky130_fd_sc_hd__or3_1
X_09330_ _02422_ _04640_ _02421_ VSS VSS VDD VDD _04641_ sky130_fd_sc_hd__a21oi_1
X_09331_ _02427_ _04641_ VSS VSS VDD VDD stage3_out\[210\]
+ sky130_fd_sc_hd__xnor2_1
X_09332_ _04468_ _04584_ _04586_ VSS VSS VDD VDD _04642_ sky130_fd_sc_hd__and3_1
X_09333_ _04587_ _04642_ VSS VSS VDD VDD stage3_out\[211\]
+ sky130_fd_sc_hd__nor2_1
X_09334_ _02245_ _04604_ VSS VSS VDD VDD stage3_out\[212\]
+ sky130_fd_sc_hd__xor2_1
X_09335_ _04583_ _04466_ _04588_ VSS VSS VDD VDD _04643_ sky130_fd_sc_hd__and3_1
X_09336_ _04589_ _04643_ VSS VSS VDD VDD stage3_out\[213\]
+ sky130_fd_sc_hd__nor2_1
X_09337_ _02245_ _04604_ _02244_ VSS VSS VDD VDD _04644_ sky130_fd_sc_hd__a21oi_1
X_09338_ _04466_ _04644_ VSS VSS VDD VDD _04645_ sky130_fd_sc_hd__nor2_1
X_09339_ _02268_ _04645_ VSS VSS VDD VDD _04646_ sky130_fd_sc_hd__nor2_1
X_09340_ _02291_ _04646_ VSS VSS VDD VDD stage3_out\[214\]
+ sky130_fd_sc_hd__xnor2_1
X_09341_ _04582_ _04465_ _04590_ VSS VSS VDD VDD _04647_ sky130_fd_sc_hd__and3_1
X_09342_ _04591_ _04647_ VSS VSS VDD VDD stage3_out\[215\]
+ sky130_fd_sc_hd__nor2_1
X_09343_ _02437_ _04612_ VSS VSS VDD VDD stage3_out\[216\]
+ sky130_fd_sc_hd__xnor2_1
X_09344_ stage3_in_r\[53\] stage3_in_r\[54\] stage3_in_r\[55\]
+ VSS VSS VDD VDD _04648_ sky130_fd_sc_hd__nor3_1
Xinput102 in_flat[47] VSS VSS VDD VDD net101 sky130_fd_sc_hd__clkdlybuf4s50_1
Xinput101 in_flat[46] VSS VSS VDD VDD net100 sky130_fd_sc_hd__clkdlybuf4s50_1
X_09347_ stage3_in_r\[50\] _01128_ VSS VSS VDD VDD _04651_
+ sky130_fd_sc_hd__nand2b_1
Xinput100 in_flat[45] VSS VSS VDD VDD net99 sky130_fd_sc_hd__clkdlybuf4s50_1
X_09349_ stage3_in_r\[51\] stage3_in_r\[52\] _04651_ VSS VSS
+ VDD VDD _04653_ sky130_fd_sc_hd__nor3_1
X_09350_ _04648_ _04653_ VSS VSS VDD VDD _04654_ sky130_fd_sc_hd__nand2_1
X_09351_ stage3_in_r\[56\] stage3_in_r\[57\] _04654_ VSS VSS
+ VDD VDD _04655_ sky130_fd_sc_hd__nor3_1
X_09352_ stage3_in_r\[58\] _04655_ VSS VSS VDD VDD stage3_out\[169\]
+ sky130_fd_sc_hd__xnor2_1
X_09353_ stage3_in_r\[56\] stage3_in_r\[57\] stage3_in_r\[58\]
+ VSS VSS VDD VDD _04656_ sky130_fd_sc_hd__nor3_1
X_09354_ stage3_in_r\[50\] stage3_in_r\[49\] stage3_in_r\[48\]
+ VSS VSS VDD VDD _04657_ sky130_fd_sc_hd__or3_1
Xinput99 in_flat[44] VSS VSS VDD VDD net98 sky130_fd_sc_hd__clkdlybuf4s50_1
X_09356_ stage3_in_r\[51\] stage3_in_r\[52\] _04657_ VSS VSS
+ VDD VDD _04659_ sky130_fd_sc_hd__nor3_1
X_09357_ _04648_ _04656_ _04659_ VSS VSS VDD VDD _04660_ sky130_fd_sc_hd__nand3_1
X_09358_ stage3_in_r\[59\] _04660_ VSS VSS VDD VDD stage3_out\[170\]
+ sky130_fd_sc_hd__xor2_1
X_09359_ stage3_in_r\[59\] _04648_ _04653_ _04656_ VSS VSS
+ VDD VDD _04661_ sky130_fd_sc_hd__nand4b_1
X_09360_ stage3_in_r\[60\] _04661_ VSS VSS VDD VDD stage3_out\[171\]
+ sky130_fd_sc_hd__xor2_1
X_09361_ stage3_in_r\[59\] stage3_in_r\[60\] _04660_ VSS VSS
+ VDD VDD _04662_ sky130_fd_sc_hd__nor3_1
X_09362_ stage3_in_r\[61\] _04662_ VSS VSS VDD VDD stage3_out\[172\]
+ sky130_fd_sc_hd__xnor2_1
X_09363_ stage3_in_r\[59\] stage3_in_r\[60\] stage3_in_r\[61\]
+ VSS VSS VDD VDD _04663_ sky130_fd_sc_hd__nor3_1
X_09364_ _04648_ _04653_ _04656_ _04663_ VSS VSS VDD VDD _04664_
+ sky130_fd_sc_hd__nand4_1
X_09365_ stage3_in_r\[62\] _04664_ VSS VSS VDD VDD _04665_
+ sky130_fd_sc_hd__xnor2_1
X_09366_ _04665_ VSS VSS VDD VDD stage3_out\[173\] sky130_fd_sc_hd__inv_1
X_09367_ stage3_in_r\[62\] _04660_ _04663_ VSS VSS VDD VDD
+ _04666_ sky130_fd_sc_hd__nor3b_1
X_09368_ stage3_in_r\[63\] _04666_ VSS VSS VDD VDD stage3_out\[174\]
+ sky130_fd_sc_hd__xnor2_1
X_09369_ _01128_ stage3_in_r\[50\] VSS VSS VDD VDD stage3_out\[161\]
+ sky130_fd_sc_hd__xnor2_1
X_09370_ stage3_in_r\[51\] _04657_ VSS VSS VDD VDD stage3_out\[162\]
+ sky130_fd_sc_hd__xor2_1
X_09371_ stage3_in_r\[51\] _04651_ stage3_in_r\[52\] VSS VSS
+ VDD VDD _04667_ sky130_fd_sc_hd__o21a_1
X_09372_ _04653_ _04667_ VSS VSS VDD VDD stage3_out\[163\]
+ sky130_fd_sc_hd__nor2_1
X_09373_ stage3_in_r\[53\] _04659_ VSS VSS VDD VDD stage3_out\[164\]
+ sky130_fd_sc_hd__xnor2_1
X_09374_ stage3_in_r\[51\] stage3_in_r\[52\] stage3_in_r\[53\]
+ _04651_ VSS VSS VDD VDD _04668_ sky130_fd_sc_hd__nor4_1
X_09375_ stage3_in_r\[54\] _04668_ VSS VSS VDD VDD stage3_out\[165\]
+ sky130_fd_sc_hd__xnor2_1
X_09376_ stage3_in_r\[53\] stage3_in_r\[54\] VSS VSS VDD VDD
+ _04669_ sky130_fd_sc_hd__nor2_1
X_09377_ _04669_ _04659_ VSS VSS VDD VDD _04670_ sky130_fd_sc_hd__nand2_1
X_09378_ stage3_in_r\[55\] _04670_ VSS VSS VDD VDD stage3_out\[166\]
+ sky130_fd_sc_hd__xor2_1
X_09379_ stage3_in_r\[56\] _04654_ VSS VSS VDD VDD stage3_out\[167\]
+ sky130_fd_sc_hd__xor2_1
X_09380_ stage3_in_r\[55\] stage3_in_r\[56\] _04670_ VSS VSS
+ VDD VDD _04671_ sky130_fd_sc_hd__nor3_1
X_09381_ stage3_in_r\[57\] _04671_ VSS VSS VDD VDD stage3_out\[168\]
+ sky130_fd_sc_hd__xnor2_1
X_09382_ stage3_in_r\[52\] stage3_in_r\[53\] stage3_in_r\[54\]
+ VSS VSS VDD VDD _04672_ sky130_fd_sc_hd__and3_1
X_09383_ stage3_in_r\[52\] stage3_in_r\[53\] stage3_in_r\[54\]
+ _04651_ VSS VSS VDD VDD _04673_ sky130_fd_sc_hd__nor4_1
X_09384_ _04651_ _04672_ _04673_ VSS VSS VDD VDD _04674_ sky130_fd_sc_hd__a21oi_1
X_09385_ stage3_in_r\[51\] _04657_ _04674_ VSS VSS VDD VDD
+ _04675_ sky130_fd_sc_hd__nor3_1
X_09386_ stage3_in_r\[51\] _04657_ _04672_ _04675_ VSS VSS
+ VDD VDD _04676_ sky130_fd_sc_hd__a31oi_1
X_09387_ stage3_out\[166\] stage3_out\[167\] _04676_ VSS VSS
+ VDD VDD _04677_ sky130_fd_sc_hd__or3_1
X_09388_ _04651_ stage3_out\[168\] _04677_ VSS VSS VDD VDD
+ _04678_ sky130_fd_sc_hd__nor3_1
X_09389_ stage3_out\[169\] _04678_ VSS VSS VDD VDD stage3_out\[41\]
+ sky130_fd_sc_hd__xnor2_1
X_09390_ stage3_in_r\[48\] stage3_out\[160\] stage3_out\[161\]
+ VSS VSS VDD VDD _04679_ sky130_fd_sc_hd__or3_1
X_09391_ stage3_out\[169\] stage3_out\[168\] _04677_ _04679_
+ VSS VSS VDD VDD _04680_ sky130_fd_sc_hd__nor4_1
X_09392_ stage3_out\[170\] _04680_ VSS VSS VDD VDD stage3_out\[42\]
+ sky130_fd_sc_hd__xnor2_1
X_09393_ stage3_in_r\[50\] _01128_ VSS VSS VDD VDD _04681_
+ sky130_fd_sc_hd__nor2b_1
X_09394_ stage3_out\[169\] stage3_out\[170\] stage3_out\[168\]
+ _04677_ VSS VSS VDD VDD _04682_ sky130_fd_sc_hd__nor4_1
X_09395_ _04681_ _04682_ VSS VSS VDD VDD _04683_ sky130_fd_sc_hd__nand2_1
X_09396_ stage3_out\[171\] _04683_ VSS VSS VDD VDD stage3_out\[43\]
+ sky130_fd_sc_hd__xor2_1
X_09397_ stage3_in_r\[48\] stage3_out\[160\] stage3_out\[161\]
+ VSS VSS VDD VDD _04684_ sky130_fd_sc_hd__nor3_1
X_09398_ stage3_out\[171\] _04682_ VSS VSS VDD VDD _04685_
+ sky130_fd_sc_hd__nor2b_1
X_09399_ _04684_ _04685_ VSS VSS VDD VDD _04686_ sky130_fd_sc_hd__nand2_1
X_09400_ stage3_out\[172\] _04686_ VSS VSS VDD VDD stage3_out\[44\]
+ sky130_fd_sc_hd__xor2_1
X_09401_ stage3_out\[172\] _04685_ VSS VSS VDD VDD _04687_
+ sky130_fd_sc_hd__nor2b_1
X_09402_ _04681_ _04687_ VSS VSS VDD VDD _04688_ sky130_fd_sc_hd__nand2_1
X_09403_ _04665_ _04688_ VSS VSS VDD VDD stage3_out\[45\]
+ sky130_fd_sc_hd__xnor2_1
X_09404_ _04665_ _04684_ _04687_ VSS VSS VDD VDD _04689_ sky130_fd_sc_hd__and3_1
X_09405_ stage3_out\[174\] _04689_ VSS VSS VDD VDD stage3_out\[46\]
+ sky130_fd_sc_hd__xnor2_1
X_09406_ _04681_ _04665_ _04687_ stage3_out\[174\] VSS VSS
+ VDD VDD stage3_out\[47\] sky130_fd_sc_hd__a31oi_1
X_09407_ stage3_in_r\[48\] stage3_out\[160\] VSS VSS VDD VDD
+ stage3_out\[32\] sky130_fd_sc_hd__xor2_1
Xinput98 in_flat[43] VSS VSS VDD VDD net97 sky130_fd_sc_hd__clkdlybuf4s50_1
X_09409_ stage3_out\[162\] _04684_ VSS VSS VDD VDD stage3_out\[34\]
+ sky130_fd_sc_hd__xnor2_1
X_09410_ _04681_ _04657_ VSS VSS VDD VDD _04690_ sky130_fd_sc_hd__nand2_1
X_09411_ stage3_in_r\[52\] _04690_ VSS VSS VDD VDD stage3_out\[35\]
+ sky130_fd_sc_hd__xnor2_1
X_09412_ stage3_out\[162\] stage3_out\[163\] VSS VSS VDD VDD
+ _04691_ sky130_fd_sc_hd__or2_2
X_09413_ _04679_ _04691_ VSS VSS VDD VDD _04692_ sky130_fd_sc_hd__nor2_1
X_09414_ stage3_out\[164\] _04692_ VSS VSS VDD VDD stage3_out\[36\]
+ sky130_fd_sc_hd__xnor2_1
X_09415_ _04651_ stage3_out\[164\] _04691_ VSS VSS VDD VDD
+ _04693_ sky130_fd_sc_hd__nor3_1
X_09416_ stage3_out\[165\] _04693_ VSS VSS VDD VDD stage3_out\[37\]
+ sky130_fd_sc_hd__xnor2_1
X_09417_ _04676_ _04679_ VSS VSS VDD VDD _04694_ sky130_fd_sc_hd__nor2_1
X_09418_ stage3_out\[166\] _04694_ VSS VSS VDD VDD stage3_out\[38\]
+ sky130_fd_sc_hd__xnor2_1
X_09419_ _04651_ stage3_out\[166\] _04676_ VSS VSS VDD VDD
+ _04695_ sky130_fd_sc_hd__nor3_1
X_09420_ stage3_out\[167\] _04695_ VSS VSS VDD VDD stage3_out\[39\]
+ sky130_fd_sc_hd__xnor2_1
X_09421_ _04677_ _04679_ VSS VSS VDD VDD _04696_ sky130_fd_sc_hd__nor2_1
X_09422_ stage3_out\[168\] _04696_ VSS VSS VDD VDD stage3_out\[40\]
+ sky130_fd_sc_hd__xnor2_1
Xinput97 in_flat[42] VSS VSS VDD VDD net96 sky130_fd_sc_hd__clkdlybuf4s50_1
Xinput96 in_flat[41] VSS VSS VDD VDD net95 sky130_fd_sc_hd__clkdlybuf4s50_1
X_09425_ _01728_ VSS VSS VDD VDD _04699_ sky130_fd_sc_hd__inv_1
X_09426_ _01706_ VSS VSS VDD VDD _04700_ sky130_fd_sc_hd__inv_1
Xinput95 in_flat[40] VSS VSS VDD VDD net94 sky130_fd_sc_hd__clkdlybuf4s50_1
Xinput94 in_flat[3] VSS VSS VDD VDD net93 sky130_fd_sc_hd__clkdlybuf4s50_1
X_09429_ _01776_ VSS VSS VDD VDD _04703_ sky130_fd_sc_hd__inv_1
X_09430_ _01771_ VSS VSS VDD VDD _04704_ sky130_fd_sc_hd__inv_1
Xinput93 in_flat[39] VSS VSS VDD VDD net92 sky130_fd_sc_hd__clkdlybuf4s50_1
X_09432_ _01766_ _01114_ _01768_ VSS VSS VDD VDD _04706_ sky130_fd_sc_hd__o21bai_1
X_09433_ _04704_ _04706_ _01773_ VSS VSS VDD VDD _04707_ sky130_fd_sc_hd__a21o_1
X_09434_ _04703_ _04707_ _01778_ VSS VSS VDD VDD _04708_ sky130_fd_sc_hd__a21oi_1
X_09435_ _01695_ _04708_ _01697_ VSS VSS VDD VDD _04709_ sky130_fd_sc_hd__o21bai_1
X_09436_ _04700_ _04709_ _01708_ VSS VSS VDD VDD _04710_ sky130_fd_sc_hd__a21oi_1
X_09437_ _01717_ _04710_ _01719_ VSS VSS VDD VDD _04711_ sky130_fd_sc_hd__o21bai_1
X_09438_ _04699_ _04711_ _01730_ VSS VSS VDD VDD _04712_ sky130_fd_sc_hd__a21oi_1
X_09439_ _01781_ _04712_ _01783_ VSS VSS VDD VDD _04713_ sky130_fd_sc_hd__o21bai_1
X_09440_ _01786_ _04713_ VSS VSS VDD VDD stage3_out\[9\] sky130_fd_sc_hd__xnor2_1
X_09441_ stage3_in_r\[128\] _01763_ _01768_ VSS VSS VDD VDD
+ _04714_ sky130_fd_sc_hd__or3_1
X_09442_ _01763_ _01762_ VSS VSS VDD VDD _04715_ sky130_fd_sc_hd__nor2b_1
X_09443_ _01766_ _04715_ _01768_ VSS VSS VDD VDD _04716_ sky130_fd_sc_hd__o21bai_1
X_09444_ _01695_ _01776_ VSS VSS VDD VDD _04717_ sky130_fd_sc_hd__nor2_1
X_09445_ net415 _04714_ _04716_ _04717_ _04704_ VSS VSS VDD
+ VDD _04718_ sky130_fd_sc_hd__o2111ai_1
X_09446_ _01695_ _01778_ VSS VSS VDD VDD _04719_ sky130_fd_sc_hd__nor2b_1
X_09447_ _01773_ _04717_ _04719_ VSS VSS VDD VDD _04720_ sky130_fd_sc_hd__a21oi_1
X_09448_ _01697_ _01708_ _01719_ VSS VSS VDD VDD _04721_ sky130_fd_sc_hd__nor3_1
X_09449_ _01717_ VSS VSS VDD VDD _04722_ sky130_fd_sc_hd__inv_1
X_09450_ _01708_ _01706_ VSS VSS VDD VDD _04723_ sky130_fd_sc_hd__nand2b_1
X_09451_ _04722_ _04723_ _01719_ VSS VSS VDD VDD _04724_ sky130_fd_sc_hd__a21oi_1
X_09452_ _04718_ _04720_ _04721_ _04724_ VSS VSS VDD VDD _04725_
+ sky130_fd_sc_hd__a31oi_1
X_09453_ _01728_ _01781_ _01786_ VSS VSS VDD VDD _04726_ sky130_fd_sc_hd__nor3_1
X_09454_ _04725_ _04726_ VSS VSS VDD VDD _04727_ sky130_fd_sc_hd__nand2_1
X_09455_ _01781_ _01730_ VSS VSS VDD VDD _04728_ sky130_fd_sc_hd__nor2b_1
X_09456_ _01786_ VSS VSS VDD VDD _04729_ sky130_fd_sc_hd__inv_1
X_09457_ _01783_ _04728_ _04729_ VSS VSS VDD VDD _04730_ sky130_fd_sc_hd__o21ai_0
X_09458_ _01788_ _04727_ _04730_ VSS VSS VDD VDD _04731_ sky130_fd_sc_hd__and3b_1
X_09459_ net411 _04731_ VSS VSS VDD VDD stage3_out\[10\] sky130_fd_sc_hd__xor2_1
X_09460_ _04729_ _04713_ _01788_ VSS VSS VDD VDD _04732_ sky130_fd_sc_hd__a21oi_1
X_09461_ net411 _04732_ _01793_ VSS VSS VDD VDD _04733_ sky130_fd_sc_hd__o21bai_1
X_09462_ _01796_ _04733_ VSS VSS VDD VDD stage3_out\[11\]
+ sky130_fd_sc_hd__xnor2_1
X_09463_ _01788_ _01793_ _01798_ VSS VSS VDD VDD _04734_ sky130_fd_sc_hd__nor3_1
X_09464_ _01796_ VSS VSS VDD VDD _04735_ sky130_fd_sc_hd__inv_1
X_09465_ _01793_ net411 VSS VSS VDD VDD _04736_ sky130_fd_sc_hd__nand2b_1
X_09466_ _04735_ _04736_ _01798_ VSS VSS VDD VDD _04737_ sky130_fd_sc_hd__a21oi_1
X_09467_ _04727_ _04730_ _04734_ _04737_ VSS VSS VDD VDD _04738_
+ sky130_fd_sc_hd__a31oi_1
X_09468_ _01801_ _04738_ VSS VSS VDD VDD stage3_out\[12\]
+ sky130_fd_sc_hd__xnor2_1
X_09469_ _04735_ _04733_ _01798_ VSS VSS VDD VDD _04739_ sky130_fd_sc_hd__a21oi_1
X_09470_ _01801_ _04739_ VSS VSS VDD VDD _04740_ sky130_fd_sc_hd__nor2_1
X_09471_ _01803_ _04740_ VSS VSS VDD VDD _04741_ sky130_fd_sc_hd__nor2_1
X_09472_ _01806_ _04741_ VSS VSS VDD VDD stage3_out\[13\]
+ sky130_fd_sc_hd__xor2_1
Xinput92 in_flat[38] VSS VSS VDD VDD net91 sky130_fd_sc_hd__clkdlybuf4s50_1
X_09474_ _01801_ VSS VSS VDD VDD _04743_ sky130_fd_sc_hd__inv_1
X_09475_ _04743_ _04738_ _01803_ VSS VSS VDD VDD _04744_ sky130_fd_sc_hd__a21oi_1
X_09476_ _01806_ _04744_ _01808_ VSS VSS VDD VDD _04745_ sky130_fd_sc_hd__o21bai_1
X_09477_ _01811_ _04745_ VSS VSS VDD VDD stage3_out\[14\]
+ sky130_fd_sc_hd__xnor2_1
X_09478_ _01808_ _01811_ _01813_ VSS VSS VDD VDD _04746_ sky130_fd_sc_hd__nor3_1
X_09479_ _01806_ _04741_ _04746_ VSS VSS VDD VDD _04747_ sky130_fd_sc_hd__o21ai_0
X_09480_ _01811_ _01813_ VSS VSS VDD VDD _04748_ sky130_fd_sc_hd__nand2_1
X_09481_ _04747_ _04748_ VSS VSS VDD VDD stage3_out\[15\]
+ sky130_fd_sc_hd__nand2_1
X_09482_ _01766_ _01114_ VSS VSS VDD VDD stage3_out\[1\] sky130_fd_sc_hd__xor2_1
X_09483_ net415 _04714_ _04716_ VSS VSS VDD VDD _04749_ sky130_fd_sc_hd__o21a_1
X_09484_ _01771_ _04749_ VSS VSS VDD VDD stage3_out\[2\] sky130_fd_sc_hd__xnor2_1
X_09485_ _01776_ _04707_ VSS VSS VDD VDD stage3_out\[3\] sky130_fd_sc_hd__xnor2_1
X_09486_ _04704_ _04749_ _01773_ VSS VSS VDD VDD _04750_ sky130_fd_sc_hd__a21oi_1
X_09487_ _01776_ _04750_ VSS VSS VDD VDD _04751_ sky130_fd_sc_hd__nor2_1
X_09488_ _01778_ _04751_ VSS VSS VDD VDD _04752_ sky130_fd_sc_hd__nor2_1
X_09489_ _01695_ _04752_ VSS VSS VDD VDD stage3_out\[4\] sky130_fd_sc_hd__xor2_1
X_09490_ _01706_ _04709_ VSS VSS VDD VDD stage3_out\[5\] sky130_fd_sc_hd__xnor2_1
X_09491_ _01697_ _04718_ _04720_ VSS VSS VDD VDD _04753_ sky130_fd_sc_hd__nand3b_1
X_09492_ _04700_ _04753_ _01708_ VSS VSS VDD VDD _04754_ sky130_fd_sc_hd__a21oi_1
X_09493_ _04722_ _04754_ VSS VSS VDD VDD stage3_out\[6\] sky130_fd_sc_hd__xnor2_1
X_09494_ _01728_ _04711_ VSS VSS VDD VDD stage3_out\[7\] sky130_fd_sc_hd__xnor2_1
X_09495_ _04699_ _04725_ _01730_ VSS VSS VDD VDD _04755_ sky130_fd_sc_hd__a21oi_1
X_09496_ _01781_ _04755_ VSS VSS VDD VDD stage3_out\[8\] sky130_fd_sc_hd__xor2_1
Xinput91 in_flat[37] VSS VSS VDD VDD net90 sky130_fd_sc_hd__clkdlybuf4s50_1
Xinput90 in_flat[36] VSS VSS VDD VDD net89 sky130_fd_sc_hd__clkdlybuf4s50_1
X_09499_ _01422_ VSS VSS VDD VDD _04758_ sky130_fd_sc_hd__inv_1
X_09500_ _01378_ VSS VSS VDD VDD _04759_ sky130_fd_sc_hd__inv_1
Xinput89 in_flat[35] VSS VSS VDD VDD net88 sky130_fd_sc_hd__clkdlybuf4s50_1
Xinput88 in_flat[34] VSS VSS VDD VDD net87 sky130_fd_sc_hd__clkdlybuf4s50_1
X_09503_ _01556_ VSS VSS VDD VDD _04762_ sky130_fd_sc_hd__inv_1
X_09504_ _01551_ VSS VSS VDD VDD _04763_ sky130_fd_sc_hd__inv_1
Xinput87 in_flat[33] VSS VSS VDD VDD net86 sky130_fd_sc_hd__clkdlybuf4s50_1
X_09506_ _01546_ _01119_ _01548_ VSS VSS VDD VDD _04765_ sky130_fd_sc_hd__o21bai_1
X_09507_ _04763_ _04765_ _01553_ VSS VSS VDD VDD _04766_ sky130_fd_sc_hd__a21o_1
X_09508_ _04762_ _04766_ _01558_ VSS VSS VDD VDD _04767_ sky130_fd_sc_hd__a21oi_1
X_09509_ _01354_ _04767_ _01356_ VSS VSS VDD VDD _04768_ sky130_fd_sc_hd__o21bai_1
X_09510_ _04759_ _04768_ _01380_ VSS VSS VDD VDD _04769_ sky130_fd_sc_hd__a21oi_1
X_09511_ _01401_ _04769_ _01403_ VSS VSS VDD VDD _04770_ sky130_fd_sc_hd__o21bai_1
X_09512_ _04758_ _04770_ _01424_ VSS VSS VDD VDD _04771_ sky130_fd_sc_hd__a21oi_1
X_09513_ _01561_ _04771_ _01563_ VSS VSS VDD VDD _04772_ sky130_fd_sc_hd__o21bai_1
X_09514_ _01566_ _04772_ VSS VSS VDD VDD stage3_out\[25\]
+ sky130_fd_sc_hd__xnor2_1
Xinput86 in_flat[32] VSS VSS VDD VDD net85 sky130_fd_sc_hd__clkdlybuf4s50_1
X_09516_ _01546_ _01542_ _01551_ VSS VSS VDD VDD _04774_ sky130_fd_sc_hd__nor3_1
X_09517_ net458 _03043_ _04774_ VSS VSS VDD VDD _04775_ sky130_fd_sc_hd__o21ai_1
X_09518_ _01546_ _01543_ VSS VSS VDD VDD _04776_ sky130_fd_sc_hd__nor2b_1
X_09519_ _01548_ _04776_ _04763_ VSS VSS VDD VDD _04777_ sky130_fd_sc_hd__o21ai_0
X_09520_ _01553_ _01558_ _01356_ VSS VSS VDD VDD _04778_ sky130_fd_sc_hd__nor3_1
X_09521_ _04775_ _04777_ _04778_ VSS VSS VDD VDD _04779_ sky130_fd_sc_hd__nand3_1
X_09522_ _01558_ VSS VSS VDD VDD _04780_ sky130_fd_sc_hd__inv_1
X_09523_ _01556_ _04780_ _01354_ VSS VSS VDD VDD _04781_ sky130_fd_sc_hd__a21oi_1
X_09524_ _01356_ _04781_ VSS VSS VDD VDD _04782_ sky130_fd_sc_hd__nor2_1
X_09525_ _01378_ _04782_ VSS VSS VDD VDD _04783_ sky130_fd_sc_hd__nor2_1
X_09526_ _01401_ _01422_ VSS VSS VDD VDD _04784_ sky130_fd_sc_hd__nor2_1
X_09527_ _01401_ VSS VSS VDD VDD _04785_ sky130_fd_sc_hd__inv_1
X_09528_ _04785_ _01380_ _01403_ VSS VSS VDD VDD _04786_ sky130_fd_sc_hd__a21oi_1
X_09529_ _01422_ _04786_ VSS VSS VDD VDD _04787_ sky130_fd_sc_hd__nor2_1
X_09530_ _04779_ _04783_ _04784_ _04787_ VSS VSS VDD VDD _04788_
+ sky130_fd_sc_hd__a31oi_1
X_09531_ _01424_ _01563_ _01568_ VSS VSS VDD VDD _04789_ sky130_fd_sc_hd__nor3_1
X_09532_ _01566_ VSS VSS VDD VDD _04790_ sky130_fd_sc_hd__inv_1
X_09533_ _01563_ _01561_ VSS VSS VDD VDD _04791_ sky130_fd_sc_hd__nand2b_1
X_09534_ _04790_ _04791_ _01568_ VSS VSS VDD VDD _04792_ sky130_fd_sc_hd__a21oi_1
X_09535_ _04788_ _04789_ _04792_ VSS VSS VDD VDD _04793_ sky130_fd_sc_hd__a21oi_1
X_09536_ _01571_ _04793_ VSS VSS VDD VDD stage3_out\[26\]
+ sky130_fd_sc_hd__xnor2_1
Xinput85 in_flat[31] VSS VSS VDD VDD net84 sky130_fd_sc_hd__clkdlybuf4s50_1
X_09538_ _04790_ _04772_ _01568_ VSS VSS VDD VDD _04795_ sky130_fd_sc_hd__a21oi_1
X_09539_ _01571_ _04795_ _01573_ VSS VSS VDD VDD _04796_ sky130_fd_sc_hd__o21bai_1
X_09540_ _01576_ _04796_ VSS VSS VDD VDD stage3_out\[27\]
+ sky130_fd_sc_hd__xnor2_1
Xinput84 in_flat[30] VSS VSS VDD VDD net83 sky130_fd_sc_hd__clkdlybuf4s50_1
X_09542_ _01576_ VSS VSS VDD VDD _04798_ sky130_fd_sc_hd__inv_1
X_09543_ _01571_ _01576_ VSS VSS VDD VDD _04799_ sky130_fd_sc_hd__nor2_1
X_09544_ _01573_ _04798_ _04793_ _04799_ _01578_ VSS VSS VDD
+ VDD _04800_ sky130_fd_sc_hd__a221o_1
X_09545_ _01581_ _04800_ VSS VSS VDD VDD stage3_out\[28\]
+ sky130_fd_sc_hd__xnor2_1
X_09546_ _01586_ VSS VSS VDD VDD _04801_ sky130_fd_sc_hd__inv_1
X_09547_ _04798_ _04796_ _01578_ VSS VSS VDD VDD _04802_ sky130_fd_sc_hd__a21oi_1
X_09548_ _01581_ _04802_ VSS VSS VDD VDD _04803_ sky130_fd_sc_hd__nor2_1
X_09549_ _01583_ _04803_ VSS VSS VDD VDD _04804_ sky130_fd_sc_hd__nor2_1
X_09550_ _04801_ _04804_ VSS VSS VDD VDD stage3_out\[29\]
+ sky130_fd_sc_hd__xnor2_1
Xinput83 in_flat[2] VSS VSS VDD VDD net82 sky130_fd_sc_hd__clkdlybuf4s50_1
X_09552_ _01581_ _01586_ VSS VSS VDD VDD _04806_ sky130_fd_sc_hd__nor2_1
X_09553_ _01591_ _04800_ _04806_ VSS VSS VDD VDD _04807_ sky130_fd_sc_hd__nand3_1
X_09554_ _01583_ _01588_ _01591_ _04800_ VSS VSS VDD VDD _04808_
+ sky130_fd_sc_hd__or4_1
X_09555_ _01583_ _01581_ VSS VSS VDD VDD _04809_ sky130_fd_sc_hd__nand2b_1
X_09556_ _04801_ _04809_ _01591_ _01588_ VSS VSS VDD VDD _04810_
+ sky130_fd_sc_hd__a211o_1
X_09557_ _01586_ _01583_ VSS VSS VDD VDD _04811_ sky130_fd_sc_hd__nor2b_1
X_09558_ _01588_ _04811_ _01591_ VSS VSS VDD VDD _04812_ sky130_fd_sc_hd__o21ai_0
X_09559_ _04807_ _04808_ _04810_ _04812_ VSS VSS VDD VDD stage3_out\[30\]
+ sky130_fd_sc_hd__nand4_1
X_09560_ _01588_ _01591_ _01593_ VSS VSS VDD VDD _04813_ sky130_fd_sc_hd__nor3_1
X_09561_ _01586_ _04804_ _04813_ VSS VSS VDD VDD _04814_ sky130_fd_sc_hd__o21ai_0
X_09562_ _01591_ _01593_ VSS VSS VDD VDD _04815_ sky130_fd_sc_hd__nand2_1
X_09563_ _04814_ _04815_ VSS VSS VDD VDD stage3_out\[31\]
+ sky130_fd_sc_hd__nand2_1
X_09564_ _01546_ _01119_ VSS VSS VDD VDD stage3_out\[17\]
+ sky130_fd_sc_hd__xor2_1
X_09565_ _01546_ VSS VSS VDD VDD _04816_ sky130_fd_sc_hd__inv_1
X_09566_ _01542_ _01117_ _01543_ VSS VSS VDD VDD _04817_ sky130_fd_sc_hd__o21bai_1
X_09567_ _04816_ _04817_ _01548_ VSS VSS VDD VDD _04818_ sky130_fd_sc_hd__a21oi_1
X_09568_ _04763_ _04818_ VSS VSS VDD VDD stage3_out\[18\]
+ sky130_fd_sc_hd__xnor2_1
X_09569_ _01556_ _04766_ VSS VSS VDD VDD stage3_out\[19\]
+ sky130_fd_sc_hd__xnor2_1
X_09570_ _04775_ _04777_ VSS VSS VDD VDD _04819_ sky130_fd_sc_hd__nand2_1
X_09571_ _01553_ _04819_ VSS VSS VDD VDD _04820_ sky130_fd_sc_hd__nor2_1
X_09572_ _01556_ _04820_ _04780_ VSS VSS VDD VDD _04821_ sky130_fd_sc_hd__o21ai_0
X_09573_ _01354_ _04821_ VSS VSS VDD VDD stage3_out\[20\]
+ sky130_fd_sc_hd__xnor2_1
X_09574_ _01378_ _04768_ VSS VSS VDD VDD stage3_out\[21\]
+ sky130_fd_sc_hd__xnor2_1
X_09575_ _04779_ _04783_ _01380_ VSS VSS VDD VDD _04822_ sky130_fd_sc_hd__a21oi_1
X_09576_ _04785_ _04822_ VSS VSS VDD VDD stage3_out\[22\]
+ sky130_fd_sc_hd__xnor2_1
X_09577_ _01422_ _04770_ VSS VSS VDD VDD stage3_out\[23\]
+ sky130_fd_sc_hd__xnor2_1
X_09578_ _01424_ _04788_ VSS VSS VDD VDD _04823_ sky130_fd_sc_hd__nand2b_1
X_09579_ _01561_ _04823_ VSS VSS VDD VDD stage3_out\[24\]
+ sky130_fd_sc_hd__xnor2_1
X_09580_ _01123_ _01766_ _01765_ VSS VSS VDD VDD _04824_ sky130_fd_sc_hd__a21o_1
X_09581_ _01771_ _04824_ _01770_ VSS VSS VDD VDD _04825_ sky130_fd_sc_hd__a21oi_1
X_09582_ _04703_ _04825_ _01775_ VSS VSS VDD VDD _04826_ sky130_fd_sc_hd__o21bai_1
X_09583_ _01695_ _04826_ _01694_ VSS VSS VDD VDD _04827_ sky130_fd_sc_hd__a21oi_1
X_09584_ _04700_ _04827_ _01705_ VSS VSS VDD VDD _04828_ sky130_fd_sc_hd__o21bai_1
X_09585_ _01717_ _04828_ _01716_ VSS VSS VDD VDD _04829_ sky130_fd_sc_hd__a21oi_1
X_09586_ _04699_ _04829_ _01727_ VSS VSS VDD VDD _04830_ sky130_fd_sc_hd__o21bai_1
X_09587_ _01781_ _04830_ _01780_ VSS VSS VDD VDD _04831_ sky130_fd_sc_hd__a21oi_1
X_09588_ _01786_ _04831_ VSS VSS VDD VDD stage3_out\[137\]
+ sky130_fd_sc_hd__xnor2_1
X_09589_ stage3_in_r\[128\] _01766_ _01762_ VSS VSS VDD VDD
+ _04832_ sky130_fd_sc_hd__nand3_1
X_09590_ _01766_ _01761_ _01765_ VSS VSS VDD VDD _04833_ sky130_fd_sc_hd__a21oi_1
X_09591_ net415 _04832_ _04833_ VSS VSS VDD VDD _04834_ sky130_fd_sc_hd__o21ai_0
X_09592_ _01695_ _01775_ VSS VSS VDD VDD _04835_ sky130_fd_sc_hd__nand2_1
X_09593_ _01695_ _01776_ _01770_ VSS VSS VDD VDD _04836_ sky130_fd_sc_hd__nand3_1
X_09594_ _04835_ _04836_ VSS VSS VDD VDD _04837_ sky130_fd_sc_hd__nand2_1
X_09595_ _01695_ _01776_ _01771_ _04834_ _04837_ VSS VSS VDD
+ VDD _04838_ sky130_fd_sc_hd__a41oi_1
X_09596_ _01694_ _01705_ _01716_ VSS VSS VDD VDD _04839_ sky130_fd_sc_hd__nor3_1
X_09597_ _01706_ _01705_ _01716_ VSS VSS VDD VDD _04840_ sky130_fd_sc_hd__nor3_1
X_09598_ _01717_ _01716_ VSS VSS VDD VDD _04841_ sky130_fd_sc_hd__nor2_1
X_09599_ _01728_ _01781_ _01786_ VSS VSS VDD VDD _04842_ sky130_fd_sc_hd__nand3_1
X_09600_ _04838_ _04839_ _04840_ _04841_ _04842_ VSS VSS VDD
+ VDD _04843_ sky130_fd_sc_hd__a2111o_1
X_09601_ _01781_ _01786_ _01727_ VSS VSS VDD VDD _04844_ sky130_fd_sc_hd__and3_1
X_09602_ _01786_ _01780_ _04844_ VSS VSS VDD VDD _04845_ sky130_fd_sc_hd__a21oi_1
X_09603_ _04843_ _04845_ VSS VSS VDD VDD _04846_ sky130_fd_sc_hd__nand2_1
X_09604_ _01785_ _04846_ VSS VSS VDD VDD _04847_ sky130_fd_sc_hd__nor2_1
X_09605_ net411 _04847_ VSS VSS VDD VDD stage3_out\[138\]
+ sky130_fd_sc_hd__xnor2_1
X_09606_ _04729_ _04831_ _01785_ VSS VSS VDD VDD _04848_ sky130_fd_sc_hd__o21bai_1
X_09607_ net411 _04848_ _01790_ VSS VSS VDD VDD _04849_ sky130_fd_sc_hd__a21oi_1
X_09608_ _01796_ _04849_ VSS VSS VDD VDD stage3_out\[139\]
+ sky130_fd_sc_hd__xnor2_1
X_09609_ _01785_ _01790_ _01795_ VSS VSS VDD VDD _04850_ sky130_fd_sc_hd__nor3_1
X_09610_ _01791_ _01790_ VSS VSS VDD VDD _04851_ sky130_fd_sc_hd__or2_2
X_09611_ _01796_ _04851_ _01795_ VSS VSS VDD VDD _04852_ sky130_fd_sc_hd__a21oi_1
X_09612_ _04843_ _04845_ _04850_ _04852_ VSS VSS VDD VDD _04853_
+ sky130_fd_sc_hd__a31oi_1
X_09613_ _04743_ _04853_ VSS VSS VDD VDD stage3_out\[140\]
+ sky130_fd_sc_hd__xnor2_1
X_09614_ _04735_ _04849_ _01795_ VSS VSS VDD VDD _04854_ sky130_fd_sc_hd__o21bai_1
X_09615_ _01801_ _04854_ _01800_ VSS VSS VDD VDD _04855_ sky130_fd_sc_hd__a21oi_1
X_09616_ _01806_ _04855_ VSS VSS VDD VDD stage3_out\[141\]
+ sky130_fd_sc_hd__xnor2_1
X_09617_ _01801_ _04853_ _01800_ VSS VSS VDD VDD _04856_ sky130_fd_sc_hd__a21o_1
X_09618_ _01806_ _04856_ _01805_ VSS VSS VDD VDD _04857_ sky130_fd_sc_hd__a21oi_1
X_09619_ _01811_ _04857_ VSS VSS VDD VDD stage3_out\[142\]
+ sky130_fd_sc_hd__xnor2_1
X_09620_ _01810_ VSS VSS VDD VDD _04858_ sky130_fd_sc_hd__inv_1
X_09621_ _04855_ _01806_ VSS VSS VDD VDD _04859_ sky130_fd_sc_hd__nand2b_1
X_09622_ _01805_ _04858_ _04859_ _01811_ VSS VSS VDD VDD _04860_
+ sky130_fd_sc_hd__nand4b_1
X_09623_ _01811_ _04858_ _04860_ VSS VSS VDD VDD stage3_out\[143\]
+ sky130_fd_sc_hd__o21ai_0
X_09624_ _01123_ _01766_ VSS VSS VDD VDD stage3_out\[129\]
+ sky130_fd_sc_hd__xor2_1
X_09625_ _04704_ _04834_ VSS VSS VDD VDD stage3_out\[130\]
+ sky130_fd_sc_hd__xnor2_1
X_09626_ _01776_ _04825_ VSS VSS VDD VDD stage3_out\[131\]
+ sky130_fd_sc_hd__xnor2_1
X_09627_ _01771_ _04834_ _01770_ VSS VSS VDD VDD _04861_ sky130_fd_sc_hd__a21o_1
X_09628_ _01776_ _04861_ _01775_ VSS VSS VDD VDD _04862_ sky130_fd_sc_hd__a21oi_1
X_09629_ _01695_ _04862_ VSS VSS VDD VDD stage3_out\[132\]
+ sky130_fd_sc_hd__xnor2_1
X_09630_ _01706_ _04827_ VSS VSS VDD VDD stage3_out\[133\]
+ sky130_fd_sc_hd__xnor2_1
X_09631_ _01694_ VSS VSS VDD VDD _04863_ sky130_fd_sc_hd__inv_1
X_09632_ _04863_ _04838_ _04700_ VSS VSS VDD VDD _04864_ sky130_fd_sc_hd__a21o_1
X_09633_ _01705_ _04864_ VSS VSS VDD VDD _04865_ sky130_fd_sc_hd__nand2b_1
X_09634_ _04722_ _04865_ VSS VSS VDD VDD stage3_out\[134\]
+ sky130_fd_sc_hd__xnor2_1
X_09635_ _01728_ _04829_ VSS VSS VDD VDD stage3_out\[135\]
+ sky130_fd_sc_hd__xnor2_1
X_09636_ _01717_ _04865_ _01716_ VSS VSS VDD VDD _04866_ sky130_fd_sc_hd__a21oi_1
X_09637_ _04699_ _04866_ _01727_ VSS VSS VDD VDD _04867_ sky130_fd_sc_hd__o21bai_1
X_09638_ _01781_ _04867_ VSS VSS VDD VDD stage3_out\[136\]
+ sky130_fd_sc_hd__xor2_1
X_09639_ _01125_ _01546_ _01545_ VSS VSS VDD VDD _04868_ sky130_fd_sc_hd__a21oi_1
X_09640_ _04763_ _04868_ VSS VSS VDD VDD _04869_ sky130_fd_sc_hd__nor2_1
X_09641_ _01550_ _04869_ VSS VSS VDD VDD _04870_ sky130_fd_sc_hd__nor2_1
X_09642_ _04762_ _04870_ _01555_ VSS VSS VDD VDD _04871_ sky130_fd_sc_hd__o21bai_1
X_09643_ _01354_ _04871_ _01353_ VSS VSS VDD VDD _04872_ sky130_fd_sc_hd__a21oi_1
X_09644_ _04759_ _04872_ _01377_ VSS VSS VDD VDD _04873_ sky130_fd_sc_hd__o21bai_1
X_09645_ _01401_ _04873_ _01400_ VSS VSS VDD VDD _04874_ sky130_fd_sc_hd__a21oi_1
X_09646_ _04758_ _04874_ _01421_ VSS VSS VDD VDD _04875_ sky130_fd_sc_hd__o21bai_1
X_09647_ _01561_ _04875_ _01560_ VSS VSS VDD VDD _04876_ sky130_fd_sc_hd__a21oi_1
X_09648_ _01566_ _04876_ VSS VSS VDD VDD stage3_out\[153\]
+ sky130_fd_sc_hd__xnor2_1
X_09649_ _01546_ _01542_ _01551_ VSS VSS VDD VDD _04877_ sky130_fd_sc_hd__nand3_1
X_09650_ _01546_ _01551_ _01541_ VSS VSS VDD VDD _04878_ sky130_fd_sc_hd__and3_1
X_09651_ _01551_ _01545_ _04878_ VSS VSS VDD VDD _04879_ sky130_fd_sc_hd__a21oi_1
X_09652_ _01353_ _01550_ _01555_ VSS VSS VDD VDD _04880_ sky130_fd_sc_hd__nor3_1
X_09653_ _03040_ _03043_ _04877_ _04879_ _04880_ VSS VSS VDD
+ VDD _04881_ sky130_fd_sc_hd__o311ai_0
X_09654_ _01556_ _01353_ _01555_ VSS VSS VDD VDD _04882_ sky130_fd_sc_hd__nor3_1
X_09655_ _01354_ _01353_ VSS VSS VDD VDD _04883_ sky130_fd_sc_hd__nor2_1
X_09656_ _04882_ _04883_ VSS VSS VDD VDD _04884_ sky130_fd_sc_hd__nor2_1
X_09657_ _01378_ _04881_ _04884_ _01377_ VSS VSS VDD VDD _04885_
+ sky130_fd_sc_hd__a31oi_1
X_09658_ _01401_ _01422_ _01561_ VSS VSS VDD VDD _04886_ sky130_fd_sc_hd__nand3_1
X_09659_ _01422_ _01400_ _01421_ VSS VSS VDD VDD _04887_ sky130_fd_sc_hd__a21o_1
X_09660_ _01561_ _04887_ _01560_ VSS VSS VDD VDD _04888_ sky130_fd_sc_hd__a21oi_1
X_09661_ _04885_ _04886_ _04888_ VSS VSS VDD VDD _04889_ sky130_fd_sc_hd__o21ai_0
X_09662_ _01566_ _04889_ _01565_ VSS VSS VDD VDD _04890_ sky130_fd_sc_hd__a21oi_1
X_09663_ _01571_ _04890_ VSS VSS VDD VDD stage3_out\[154\]
+ sky130_fd_sc_hd__xnor2_1
X_09664_ _04790_ _04876_ _01565_ VSS VSS VDD VDD _04891_ sky130_fd_sc_hd__o21bai_1
X_09665_ _01571_ _04891_ _01570_ VSS VSS VDD VDD _04892_ sky130_fd_sc_hd__a21oi_1
X_09666_ _01576_ _04892_ VSS VSS VDD VDD stage3_out\[155\]
+ sky130_fd_sc_hd__xnor2_1
X_09667_ _01566_ _01571_ _01576_ _04889_ VSS VSS VDD VDD _04893_
+ sky130_fd_sc_hd__nand4_1
X_09668_ _01576_ _01570_ VSS VSS VDD VDD _04894_ sky130_fd_sc_hd__nand2_1
X_09669_ _01571_ _01576_ _01565_ VSS VSS VDD VDD _04895_ sky130_fd_sc_hd__nand3_1
X_09670_ _04893_ _04894_ _04895_ VSS VSS VDD VDD _04896_ sky130_fd_sc_hd__nand3_1
X_09671_ _01575_ _04896_ VSS VSS VDD VDD _04897_ sky130_fd_sc_hd__nor2_1
X_09672_ _01581_ _04897_ VSS VSS VDD VDD stage3_out\[156\]
+ sky130_fd_sc_hd__xnor2_1
X_09673_ _04798_ _04892_ _01575_ VSS VSS VDD VDD _04898_ sky130_fd_sc_hd__o21bai_1
X_09674_ _01581_ _04898_ _01580_ VSS VSS VDD VDD _04899_ sky130_fd_sc_hd__a21oi_1
X_09675_ _01586_ _04899_ VSS VSS VDD VDD stage3_out\[157\]
+ sky130_fd_sc_hd__xnor2_1
X_09676_ _01581_ _01580_ VSS VSS VDD VDD _04900_ sky130_fd_sc_hd__nor2_1
X_09677_ _04801_ _04900_ _01585_ VSS VSS VDD VDD _04901_ sky130_fd_sc_hd__o21bai_1
X_09678_ _01575_ _01580_ _01585_ _04896_ _04901_ VSS VSS VDD
+ VDD _04902_ sky130_fd_sc_hd__o41ai_1
X_09679_ _01591_ _04902_ VSS VSS VDD VDD stage3_out\[158\]
+ sky130_fd_sc_hd__xnor2_1
X_09680_ _01590_ VSS VSS VDD VDD _04903_ sky130_fd_sc_hd__inv_1
X_09681_ _01585_ _01590_ _01591_ VSS VSS VDD VDD _04904_ sky130_fd_sc_hd__nor3b_1
X_09682_ _04801_ _04899_ _04904_ VSS VSS VDD VDD _04905_ sky130_fd_sc_hd__o21ai_0
X_09683_ _01591_ _04903_ _04905_ VSS VSS VDD VDD stage3_out\[159\]
+ sky130_fd_sc_hd__o21ai_0
X_09684_ _01125_ _01546_ VSS VSS VDD VDD stage3_out\[145\]
+ sky130_fd_sc_hd__xor2_1
X_09685_ _01542_ _01124_ _01541_ VSS VSS VDD VDD _04906_ sky130_fd_sc_hd__a21oi_1
X_09686_ _04816_ _04906_ _01545_ VSS VSS VDD VDD _04907_ sky130_fd_sc_hd__o21ba_2
X_09687_ _01551_ _04907_ VSS VSS VDD VDD stage3_out\[146\]
+ sky130_fd_sc_hd__xnor2_1
X_09688_ _01556_ _04870_ VSS VSS VDD VDD stage3_out\[147\]
+ sky130_fd_sc_hd__xnor2_1
X_09689_ _04763_ _04907_ VSS VSS VDD VDD _04908_ sky130_fd_sc_hd__nor2_1
X_09690_ _01550_ _04908_ _01556_ VSS VSS VDD VDD _04909_ sky130_fd_sc_hd__o21a_1
X_09691_ _01555_ _04909_ VSS VSS VDD VDD _04910_ sky130_fd_sc_hd__nor2_1
X_09692_ _01354_ _04910_ VSS VSS VDD VDD stage3_out\[148\]
+ sky130_fd_sc_hd__xnor2_1
X_09693_ _01378_ _04872_ VSS VSS VDD VDD stage3_out\[149\]
+ sky130_fd_sc_hd__xnor2_1
X_09694_ _01401_ _04885_ VSS VSS VDD VDD stage3_out\[150\]
+ sky130_fd_sc_hd__xnor2_1
X_09695_ _01422_ _04874_ VSS VSS VDD VDD stage3_out\[151\]
+ sky130_fd_sc_hd__xnor2_1
X_09696_ _04785_ _04885_ _01400_ VSS VSS VDD VDD _04911_ sky130_fd_sc_hd__o21bai_1
X_09697_ _01422_ _04911_ _01421_ VSS VSS VDD VDD _04912_ sky130_fd_sc_hd__a21oi_1
X_09698_ _01561_ _04912_ VSS VSS VDD VDD stage3_out\[152\]
+ sky130_fd_sc_hd__xnor2_1
X_09699_ _00000_ net440 _00001_ VSS VSS VDD VDD _04913_ _04914_
+ sky130_fd_sc_hd__fa_1
X_09700_ _04915_ _00002_ _04914_ VSS VSS VDD VDD _00003_ _00004_
+ sky130_fd_sc_hd__fa_1
X_09701_ net436 net435 stage3_in_r\[28\] VSS VSS VDD VDD _04916_
+ _04917_ sky130_fd_sc_hd__fa_1
X_09702_ _00006_ _00007_ _04917_ VSS VSS VDD VDD _00008_ _04918_
+ sky130_fd_sc_hd__fa_1
X_09703_ net435 stage3_in_r\[28\] stage3_in_r\[29\] VSS VSS
+ VDD VDD _00010_ _00011_ sky130_fd_sc_hd__fa_1
X_09704_ _00012_ _04919_ _00013_ VSS VSS VDD VDD _04920_ _04921_
+ sky130_fd_sc_hd__fa_1
X_09705_ _00014_ _00015_ _00016_ VSS VSS VDD VDD _04919_ _00017_
+ sky130_fd_sc_hd__fa_1
X_09706_ _00018_ _00019_ _00020_ VSS VSS VDD VDD _00021_ _00022_
+ sky130_fd_sc_hd__fa_1
X_09707_ _00025_ _00026_ _00027_ VSS VSS VDD VDD _00019_ _00028_
+ sky130_fd_sc_hd__fa_1
X_09708_ _00029_ _00030_ _04921_ VSS VSS VDD VDD _04922_ _04923_
+ sky130_fd_sc_hd__fa_1
X_09709_ _04924_ _00031_ _00032_ VSS VSS VDD VDD _00033_ _04925_
+ sky130_fd_sc_hd__fa_1
X_09710_ _00034_ _00035_ _00036_ VSS VSS VDD VDD _00037_ _00038_
+ sky130_fd_sc_hd__fa_1
X_09711_ _00039_ _00040_ _00011_ VSS VSS VDD VDD _04926_ _04927_
+ sky130_fd_sc_hd__fa_1
X_09712_ _00042_ _00025_ _00026_ VSS VSS VDD VDD _00041_ _00043_
+ sky130_fd_sc_hd__fa_1
X_09713_ net430 _00045_ _00046_ VSS VSS VDD VDD _04928_ _00047_
+ sky130_fd_sc_hd__fa_1
X_09714_ _04928_ _00048_ _04923_ VSS VSS VDD VDD _00049_ _00050_
+ sky130_fd_sc_hd__fa_1
X_09715_ _00051_ _04929_ _04925_ VSS VSS VDD VDD _00052_ _00053_
+ sky130_fd_sc_hd__fa_1
X_09716_ _04930_ _04931_ _00054_ VSS VSS VDD VDD _04929_ _04932_
+ sky130_fd_sc_hd__fa_1
X_09717_ _00055_ _00056_ _04917_ VSS VSS VDD VDD _04933_ _04934_
+ sky130_fd_sc_hd__fa_1
X_09718_ _00034_ _00042_ _00025_ VSS VSS VDD VDD _00057_ _00058_
+ sky130_fd_sc_hd__fa_1
X_09719_ _00026_ _00027_ _00059_ VSS VSS VDD VDD _00060_ _04935_
+ sky130_fd_sc_hd__fa_1
X_09720_ _00061_ _00062_ _00063_ VSS VSS VDD VDD _00064_ _00065_
+ sky130_fd_sc_hd__fa_1
X_09721_ _04936_ _04937_ _04932_ VSS VSS VDD VDD _00066_ _00067_
+ sky130_fd_sc_hd__fa_1
X_09722_ _04938_ _04939_ _04940_ VSS VSS VDD VDD _04937_ _04941_
+ sky130_fd_sc_hd__fa_1
X_09723_ _04935_ _00068_ _00058_ VSS VSS VDD VDD _00069_ _00070_
+ sky130_fd_sc_hd__fa_1
X_09724_ _00071_ _00034_ _00042_ VSS VSS VDD VDD _00068_ _04942_
+ sky130_fd_sc_hd__fa_2
X_09725_ _00072_ _00073_ _00074_ VSS VSS VDD VDD _00075_ _00076_
+ sky130_fd_sc_hd__fa_1
X_09726_ _04943_ _04944_ _04941_ VSS VSS VDD VDD _00077_ _04945_
+ sky130_fd_sc_hd__fa_1
X_09727_ _04946_ _00078_ _04947_ VSS VSS VDD VDD _04944_ _04948_
+ sky130_fd_sc_hd__fa_1
X_09728_ _00079_ _04942_ _00028_ VSS VSS VDD VDD _00080_ _00081_
+ sky130_fd_sc_hd__fa_1
X_09729_ _00082_ _00071_ _00034_ VSS VSS VDD VDD _00079_ _00083_
+ sky130_fd_sc_hd__fa_1
X_09730_ _04949_ _04950_ _04945_ VSS VSS VDD VDD _04951_ _04952_
+ sky130_fd_sc_hd__fa_1
X_09731_ _04953_ _00084_ _04948_ VSS VSS VDD VDD _04950_ _00085_
+ sky130_fd_sc_hd__fa_1
X_09732_ _00086_ _00001_ _00005_ VSS VSS VDD VDD _00087_ _00088_
+ sky130_fd_sc_hd__fa_1
X_09733_ _00089_ _00090_ _00056_ VSS VSS VDD VDD _04954_ _04955_
+ sky130_fd_sc_hd__fa_1
X_09734_ _00091_ _00082_ _00071_ VSS VSS VDD VDD _00092_ _00093_
+ sky130_fd_sc_hd__fa_1
X_09735_ _00094_ _00095_ _00096_ VSS VSS VDD VDD _00097_ _00098_
+ sky130_fd_sc_hd__fa_1
X_09736_ _04956_ _04957_ _00099_ VSS VSS VDD VDD _00100_ _00101_
+ sky130_fd_sc_hd__fa_1
X_09737_ _04958_ _00102_ _00103_ VSS VSS VDD VDD _04959_ _04960_
+ sky130_fd_sc_hd__fa_1
X_09738_ stage3_in_r\[18\] net443 net442 VSS VSS VDD VDD _04958_
+ _00104_ sky130_fd_sc_hd__fa_1
X_09739_ _00105_ _00106_ _00107_ VSS VSS VDD VDD _00108_ _00109_
+ sky130_fd_sc_hd__fa_1
X_09740_ _04961_ _04962_ _04963_ VSS VSS VDD VDD _00110_ _04964_
+ sky130_fd_sc_hd__fa_1
X_09741_ _00111_ _00112_ _04942_ VSS VSS VDD VDD _00113_ _00114_
+ sky130_fd_sc_hd__fa_1
X_09742_ stage3_in_r\[17\] stage3_in_r\[18\] net443 VSS VSS
+ VDD VDD _00115_ _04965_ sky130_fd_sc_hd__fa_1
X_09743_ _04966_ _00116_ _04964_ VSS VSS VDD VDD _04967_ _04968_
+ sky130_fd_sc_hd__fa_1
X_09744_ _00117_ _00118_ _00119_ VSS VSS VDD VDD _00120_ _00121_
+ sky130_fd_sc_hd__fa_1
X_09745_ stage3_in_r\[16\] stage3_in_r\[17\] stage3_in_r\[18\]
+ VSS VSS VDD VDD _04969_ _04970_ sky130_fd_sc_hd__fa_1
X_09746_ _04969_ _04965_ _00090_ VSS VSS VDD VDD _04971_ _04972_
+ sky130_fd_sc_hd__fa_1
X_09747_ _04973_ _04974_ _00122_ VSS VSS VDD VDD _04975_ _04976_
+ sky130_fd_sc_hd__fa_1
X_09748_ _04970_ _00123_ _00102_ VSS VSS VDD VDD _04977_ _04978_
+ sky130_fd_sc_hd__fa_1
X_09749_ _00124_ _00125_ _00126_ VSS VSS VDD VDD _00127_ _00128_
+ sky130_fd_sc_hd__fa_1
X_09750_ _00129_ _00130_ _00131_ VSS VSS VDD VDD _00132_ _00133_
+ sky130_fd_sc_hd__fa_1
X_09751_ _00134_ stage3_in_r\[6\] _00135_ VSS VSS VDD VDD
+ _04979_ _00136_ sky130_fd_sc_hd__fa_1
X_09752_ _00137_ _00138_ _00139_ VSS VSS VDD VDD _04980_ _04981_
+ sky130_fd_sc_hd__fa_1
X_09753_ stage3_in_r\[10\] stage3_in_r\[11\] stage3_in_r\[12\]
+ VSS VSS VDD VDD _00140_ _04982_ sky130_fd_sc_hd__fa_1
X_09754_ _00141_ _00142_ net429 VSS VSS VDD VDD _00144_ _00145_
+ sky130_fd_sc_hd__fa_1
X_09755_ _00141_ stage3_in_r\[14\] net459 VSS VSS VDD VDD
+ _04983_ _04984_ sky130_fd_sc_hd__fa_1
X_09756_ _00146_ _04985_ _04982_ VSS VSS VDD VDD _04986_ _04987_
+ sky130_fd_sc_hd__fa_1
X_09757_ _00147_ _00148_ _00141_ VSS VSS VDD VDD _00149_ _00150_
+ sky130_fd_sc_hd__fa_1
X_09758_ _00151_ _00152_ _04981_ VSS VSS VDD VDD _04988_ _04989_
+ sky130_fd_sc_hd__fa_1
X_09759_ _00153_ _04990_ _04991_ VSS VSS VDD VDD _00154_ _04992_
+ sky130_fd_sc_hd__fa_1
X_09760_ _00150_ _00155_ _00156_ VSS VSS VDD VDD _00157_ _00158_
+ sky130_fd_sc_hd__fa_1
X_09761_ _00162_ _00163_ _00164_ VSS VSS VDD VDD _00155_ _00165_
+ sky130_fd_sc_hd__fa_1
X_09762_ _00166_ _00167_ _04989_ VSS VSS VDD VDD _04993_ _04994_
+ sky130_fd_sc_hd__fa_1
X_09763_ _04995_ _00168_ _04992_ VSS VSS VDD VDD _00169_ _04996_
+ sky130_fd_sc_hd__fa_1
X_09764_ _00170_ _00171_ _00172_ VSS VSS VDD VDD _00173_ _00174_
+ sky130_fd_sc_hd__fa_1
X_09765_ _00175_ _00176_ _00159_ VSS VSS VDD VDD _04997_ _04998_
+ sky130_fd_sc_hd__fa_1
X_09766_ _00178_ _00162_ _00163_ VSS VSS VDD VDD _00177_ _00179_
+ sky130_fd_sc_hd__fa_1
X_09767_ stage3_in_r\[14\] _04999_ _00180_ VSS VSS VDD VDD
+ _00181_ _05000_ sky130_fd_sc_hd__fa_1
X_09768_ _00182_ _00183_ _04994_ VSS VSS VDD VDD _00184_ _00185_
+ sky130_fd_sc_hd__fa_1
X_09769_ _05000_ _05001_ _04996_ VSS VSS VDD VDD _00186_ _00187_
+ sky130_fd_sc_hd__fa_1
X_09770_ _05002_ _05003_ _00188_ VSS VSS VDD VDD _05001_ _05004_
+ sky130_fd_sc_hd__fa_1
X_09771_ _00189_ _00190_ _04982_ VSS VSS VDD VDD _05005_ _05006_
+ sky130_fd_sc_hd__fa_1
X_09772_ _00170_ _00178_ _00162_ VSS VSS VDD VDD _00191_ _00192_
+ sky130_fd_sc_hd__fa_1
X_09773_ _00163_ _00164_ _00147_ VSS VSS VDD VDD _00193_ _05007_
+ sky130_fd_sc_hd__fa_1
X_09774_ _00194_ _00195_ _00196_ VSS VSS VDD VDD _00197_ _00198_
+ sky130_fd_sc_hd__fa_1
X_09775_ _05008_ _05009_ _05004_ VSS VSS VDD VDD _00199_ _00200_
+ sky130_fd_sc_hd__fa_1
X_09776_ _05010_ _05011_ _05012_ VSS VSS VDD VDD _05009_ _05013_
+ sky130_fd_sc_hd__fa_1
X_09777_ _05007_ _00201_ _00192_ VSS VSS VDD VDD _00202_ _00203_
+ sky130_fd_sc_hd__fa_1
X_09778_ _00204_ _00170_ _00178_ VSS VSS VDD VDD _00201_ _05014_
+ sky130_fd_sc_hd__fa_1
X_09779_ _00205_ _00206_ _00207_ VSS VSS VDD VDD _00208_ _00209_
+ sky130_fd_sc_hd__fa_1
X_09780_ _05015_ _05016_ _05013_ VSS VSS VDD VDD _00210_ _05017_
+ sky130_fd_sc_hd__fa_1
X_09781_ _05018_ _00211_ _05019_ VSS VSS VDD VDD _05016_ _05020_
+ sky130_fd_sc_hd__fa_1
X_09782_ _00212_ _05014_ _00165_ VSS VSS VDD VDD _00213_ _00214_
+ sky130_fd_sc_hd__fa_1
X_09783_ _00215_ _00204_ _00170_ VSS VSS VDD VDD _00212_ _00216_
+ sky130_fd_sc_hd__fa_1
X_09784_ _05021_ _05022_ _05017_ VSS VSS VDD VDD _05023_ _05024_
+ sky130_fd_sc_hd__fa_1
X_09785_ _05025_ _05026_ _05020_ VSS VSS VDD VDD _05022_ _00217_
+ sky130_fd_sc_hd__fa_1
X_09786_ _05027_ _00218_ _00219_ VSS VSS VDD VDD _05026_ _05028_
+ sky130_fd_sc_hd__fa_1
X_09787_ _00220_ _00221_ _00190_ VSS VSS VDD VDD _05029_ _05030_
+ sky130_fd_sc_hd__fa_1
X_09788_ _00222_ _00215_ _00204_ VSS VSS VDD VDD _00223_ _00224_
+ sky130_fd_sc_hd__fa_1
X_09789_ _00225_ _00226_ _00227_ VSS VSS VDD VDD _00228_ _00229_
+ sky130_fd_sc_hd__fa_1
X_09790_ _05031_ _05032_ _05028_ VSS VSS VDD VDD _00230_ _00231_
+ sky130_fd_sc_hd__fa_1
X_09791_ _05033_ _00232_ _00233_ VSS VSS VDD VDD _05034_ _05035_
+ sky130_fd_sc_hd__fa_1
X_09792_ stage3_in_r\[2\] stage3_in_r\[3\] stage3_in_r\[4\]
+ VSS VSS VDD VDD _05033_ _00234_ sky130_fd_sc_hd__fa_1
X_09793_ _00235_ _00236_ _00237_ VSS VSS VDD VDD _00238_ _00239_
+ sky130_fd_sc_hd__fa_1
X_09794_ _05036_ _05037_ _05038_ VSS VSS VDD VDD _00240_ _05039_
+ sky130_fd_sc_hd__fa_1
X_09795_ _00241_ _00242_ _05014_ VSS VSS VDD VDD _00243_ _00244_
+ sky130_fd_sc_hd__fa_1
X_09796_ stage3_in_r\[1\] stage3_in_r\[2\] stage3_in_r\[3\]
+ VSS VSS VDD VDD _00245_ _05040_ sky130_fd_sc_hd__fa_1
X_09797_ _05041_ _00246_ _05039_ VSS VSS VDD VDD _05042_ _05043_
+ sky130_fd_sc_hd__fa_1
X_09798_ _00247_ _00248_ _00249_ VSS VSS VDD VDD _00250_ _00251_
+ sky130_fd_sc_hd__fa_1
X_09799_ stage3_in_r\[0\] stage3_in_r\[1\] stage3_in_r\[2\]
+ VSS VSS VDD VDD _05044_ _05045_ sky130_fd_sc_hd__fa_1
X_09800_ _05044_ _05040_ _00221_ VSS VSS VDD VDD _05046_ _05047_
+ sky130_fd_sc_hd__fa_1
X_09801_ _05048_ _05049_ _00252_ VSS VSS VDD VDD _05050_ _05051_
+ sky130_fd_sc_hd__fa_1
X_09802_ _05045_ _05052_ _00232_ VSS VSS VDD VDD _05053_ _05054_
+ sky130_fd_sc_hd__fa_1
X_09803_ _00253_ _00254_ _00255_ VSS VSS VDD VDD _00256_ _00257_
+ sky130_fd_sc_hd__fa_1
X_09804_ _00258_ _00259_ _00260_ VSS VSS VDD VDD _00261_ _00262_
+ sky130_fd_sc_hd__fa_1
X_09805_ _00263_ _00264_ _00265_ VSS VSS VDD VDD _00266_ _00267_
+ sky130_fd_sc_hd__fa_1
X_09806_ _00268_ _00269_ _00270_ VSS VSS VDD VDD _00271_ _00272_
+ sky130_fd_sc_hd__fa_1
X_09807_ net439 _00273_ _05055_ VSS VSS VDD VDD _05056_ _05057_
+ sky130_fd_sc_hd__fa_1
X_09808_ net437 _04913_ _05057_ VSS VSS VDD VDD _00274_ _00275_
+ sky130_fd_sc_hd__fa_1
X_09809_ net432 _04916_ _00011_ VSS VSS VDD VDD _00276_ _00277_
+ sky130_fd_sc_hd__fa_1
X_09810_ _00278_ _00279_ _00280_ VSS VSS VDD VDD _00281_ _05058_
+ sky130_fd_sc_hd__fa_1
X_09811_ _05058_ _00282_ _00283_ VSS VSS VDD VDD _05059_ _05060_
+ sky130_fd_sc_hd__fa_1
X_09812_ _00284_ _04920_ _05060_ VSS VSS VDD VDD _05061_ _05062_
+ sky130_fd_sc_hd__fa_1
X_09813_ _00285_ _04922_ _05062_ VSS VSS VDD VDD _00286_ _00287_
+ sky130_fd_sc_hd__fa_1
X_09814_ stage3_in_r\[7\] _00289_ _05063_ VSS VSS VDD VDD
+ _05064_ _05065_ sky130_fd_sc_hd__fa_1
X_09815_ stage3_in_r\[9\] _04979_ _05065_ VSS VSS VDD VDD
+ _00290_ _00291_ sky130_fd_sc_hd__fa_1
X_09816_ _00292_ _00293_ _00150_ VSS VSS VDD VDD _00294_ _00295_
+ sky130_fd_sc_hd__fa_1
X_09817_ _04986_ _00296_ _05066_ VSS VSS VDD VDD _05067_ _00297_
+ sky130_fd_sc_hd__fa_1
X_09818_ _00298_ _04980_ _00299_ VSS VSS VDD VDD _05068_ _05069_
+ sky130_fd_sc_hd__fa_1
X_09819_ _00300_ _04988_ _05069_ VSS VSS VDD VDD _05070_ _05071_
+ sky130_fd_sc_hd__fa_1
X_09820_ _00301_ _04993_ _05071_ VSS VSS VDD VDD _00302_ _00303_
+ sky130_fd_sc_hd__fa_1
X_09821_ net438 _00305_ _05072_ VSS VSS VDD VDD _05073_ _05074_
+ sky130_fd_sc_hd__fa_1
X_09822_ net436 _05056_ _05074_ VSS VSS VDD VDD _00306_ _00307_
+ sky130_fd_sc_hd__fa_1
X_09823_ _00308_ net428 _00044_ VSS VSS VDD VDD _00310_ _00311_
+ sky130_fd_sc_hd__fa_1
X_09824_ _00308_ stage3_in_r\[29\] net431 VSS VSS VDD VDD
+ _05075_ _05076_ sky130_fd_sc_hd__fa_1
X_09825_ _00312_ _00313_ _00314_ VSS VSS VDD VDD _05077_ _05078_
+ sky130_fd_sc_hd__fa_1
X_09826_ _00315_ _05059_ _05078_ VSS VSS VDD VDD _05079_ _05080_
+ sky130_fd_sc_hd__fa_1
X_09827_ _00316_ _05061_ _05080_ VSS VSS VDD VDD _00317_ _00318_
+ sky130_fd_sc_hd__fa_1
X_09828_ stage3_in_r\[8\] _05081_ _05082_ VSS VSS VDD VDD
+ _05083_ _05084_ sky130_fd_sc_hd__fa_1
X_09829_ stage3_in_r\[10\] _05064_ _05084_ VSS VSS VDD VDD
+ _00320_ _00321_ sky130_fd_sc_hd__fa_1
X_09830_ stage3_in_r\[12\] stage3_in_r\[13\] stage3_in_r\[14\]
+ VSS VSS VDD VDD _00322_ _05085_ sky130_fd_sc_hd__fa_1
X_09831_ net459 _05085_ _00180_ VSS VSS VDD VDD _00323_ _05086_
+ sky130_fd_sc_hd__fa_1
X_09832_ _00324_ _00325_ _00326_ VSS VSS VDD VDD _05087_ _05088_
+ sky130_fd_sc_hd__fa_1
X_09833_ _00327_ _05068_ _05088_ VSS VSS VDD VDD _05089_ _05090_
+ sky130_fd_sc_hd__fa_1
X_09834_ _00328_ _05070_ _05090_ VSS VSS VDD VDD _00329_ _00330_
+ sky130_fd_sc_hd__fa_1
X_09835_ net437 _05091_ _05092_ VSS VSS VDD VDD _05093_ _05094_
+ sky130_fd_sc_hd__fa_1
X_09836_ net435 _05073_ _05094_ VSS VSS VDD VDD _00332_ _00333_
+ sky130_fd_sc_hd__fa_1
X_09837_ _00334_ _00335_ _00336_ VSS VSS VDD VDD _05095_ _05096_
+ sky130_fd_sc_hd__fa_1
X_09838_ _00337_ _05077_ _05096_ VSS VSS VDD VDD _05097_ _05098_
+ sky130_fd_sc_hd__fa_1
X_09839_ _00338_ _05079_ _05098_ VSS VSS VDD VDD _00339_ _00340_
+ sky130_fd_sc_hd__fa_1
X_09840_ stage3_in_r\[9\] _05099_ _05100_ VSS VSS VDD VDD
+ _05101_ _05102_ sky130_fd_sc_hd__fa_1
X_09841_ stage3_in_r\[11\] _05083_ _05102_ VSS VSS VDD VDD
+ _00342_ _00343_ sky130_fd_sc_hd__fa_1
X_09842_ _00344_ _00345_ _00346_ VSS VSS VDD VDD _05103_ _05104_
+ sky130_fd_sc_hd__fa_1
X_09843_ _00347_ _05087_ _05104_ VSS VSS VDD VDD _05105_ _05106_
+ sky130_fd_sc_hd__fa_1
X_09844_ _00348_ _05089_ _05106_ VSS VSS VDD VDD _00349_ _00350_
+ sky130_fd_sc_hd__fa_1
X_09845_ net436 _05107_ _00014_ VSS VSS VDD VDD _00352_ _05108_
+ sky130_fd_sc_hd__fa_1
X_09846_ stage3_in_r\[28\] _05093_ _05108_ VSS VSS VDD VDD
+ _00353_ _00354_ sky130_fd_sc_hd__fa_1
X_09847_ _00355_ _00356_ _00357_ VSS VSS VDD VDD _05109_ _05110_
+ sky130_fd_sc_hd__fa_1
X_09848_ _00358_ _05095_ _05110_ VSS VSS VDD VDD _05111_ _05112_
+ sky130_fd_sc_hd__fa_1
X_09849_ _00359_ _05097_ _05112_ VSS VSS VDD VDD _00360_ _00361_
+ sky130_fd_sc_hd__fa_1
X_09850_ stage3_in_r\[10\] _05113_ _00362_ VSS VSS VDD VDD
+ _05114_ _05115_ sky130_fd_sc_hd__fa_1
X_09851_ stage3_in_r\[12\] _05101_ _05115_ VSS VSS VDD VDD
+ _00363_ _00364_ sky130_fd_sc_hd__fa_1
X_09852_ _00365_ _00366_ _00367_ VSS VSS VDD VDD _05116_ _05117_
+ sky130_fd_sc_hd__fa_1
X_09853_ _00368_ _05103_ _05117_ VSS VSS VDD VDD _05118_ _05119_
+ sky130_fd_sc_hd__fa_1
X_09854_ _00369_ _05105_ _05119_ VSS VSS VDD VDD _00370_ _00371_
+ sky130_fd_sc_hd__fa_1
X_09855_ net435 _05120_ _05121_ VSS VSS VDD VDD _00372_ _00373_
+ sky130_fd_sc_hd__fa_1
X_09856_ net428 _00374_ _00375_ VSS VSS VDD VDD _00376_ _05122_
+ sky130_fd_sc_hd__fa_1
X_09857_ _00377_ _00378_ _05122_ VSS VSS VDD VDD _05123_ _05124_
+ sky130_fd_sc_hd__fa_1
X_09858_ _00379_ _05109_ _05124_ VSS VSS VDD VDD _05125_ _05126_
+ sky130_fd_sc_hd__fa_1
X_09859_ _00380_ _05111_ _05126_ VSS VSS VDD VDD _00381_ _00382_
+ sky130_fd_sc_hd__fa_1
X_09860_ stage3_in_r\[11\] _05127_ _05128_ VSS VSS VDD VDD
+ _00383_ _05129_ sky130_fd_sc_hd__fa_1
X_09861_ stage3_in_r\[13\] _05114_ _05129_ VSS VSS VDD VDD
+ _00384_ _00385_ sky130_fd_sc_hd__fa_1
X_09862_ _00386_ _00387_ _00388_ VSS VSS VDD VDD _05130_ _05131_
+ sky130_fd_sc_hd__fa_1
X_09863_ _00389_ _05116_ _05131_ VSS VSS VDD VDD _05132_ _05133_
+ sky130_fd_sc_hd__fa_1
X_09864_ _00390_ _05118_ _05133_ VSS VSS VDD VDD _00391_ _00392_
+ sky130_fd_sc_hd__fa_1
X_09865_ _00308_ _00393_ _00394_ VSS VSS VDD VDD _00395_ _05134_
+ sky130_fd_sc_hd__fa_1
X_09866_ net430 _00396_ _05134_ VSS VSS VDD VDD _00397_ _00398_
+ sky130_fd_sc_hd__fa_1
X_09867_ _00399_ _05123_ _00400_ VSS VSS VDD VDD _05135_ _05136_
+ sky130_fd_sc_hd__fa_1
X_09868_ _00401_ _05125_ _05136_ VSS VSS VDD VDD _00402_ _00403_
+ sky130_fd_sc_hd__fa_1
X_09869_ stage3_in_r\[12\] _05137_ _05138_ VSS VSS VDD VDD
+ _05139_ _00404_ sky130_fd_sc_hd__fa_1
X_09870_ _00142_ _00405_ _00406_ VSS VSS VDD VDD _00407_ _05140_
+ sky130_fd_sc_hd__fa_1
X_09871_ _00408_ _00409_ _05140_ VSS VSS VDD VDD _05141_ _05142_
+ sky130_fd_sc_hd__fa_1
X_09872_ _00410_ _05130_ _05142_ VSS VSS VDD VDD _05143_ _05144_
+ sky130_fd_sc_hd__fa_1
X_09873_ _00411_ _05132_ _05144_ VSS VSS VDD VDD _00412_ _00413_
+ sky130_fd_sc_hd__fa_1
X_09874_ net428 _00414_ _00415_ VSS VSS VDD VDD _00416_ _00417_
+ sky130_fd_sc_hd__fa_1
X_09875_ net431 _00418_ _00419_ VSS VSS VDD VDD _05145_ _05146_
+ sky130_fd_sc_hd__fa_1
X_09876_ _00420_ _05135_ _00421_ VSS VSS VDD VDD _00422_ _00423_
+ sky130_fd_sc_hd__fa_1
X_09877_ _00141_ _00426_ _00427_ VSS VSS VDD VDD _00428_ _00429_
+ sky130_fd_sc_hd__fa_1
X_09878_ net459 _05139_ _00430_ VSS VSS VDD VDD _05147_ _05148_
+ sky130_fd_sc_hd__fa_1
X_09879_ _00431_ _05141_ _00432_ VSS VSS VDD VDD _05149_ _05150_
+ sky130_fd_sc_hd__fa_1
X_09880_ _00433_ _05143_ _05150_ VSS VSS VDD VDD _00434_ _00435_
+ sky130_fd_sc_hd__fa_1
X_09881_ net431 _05151_ _00436_ VSS VSS VDD VDD _00437_ _00438_
+ sky130_fd_sc_hd__fa_1
X_09882_ net430 _00439_ _00440_ VSS VSS VDD VDD _00441_ _00442_
+ sky130_fd_sc_hd__fa_1
X_09883_ _00142_ _00443_ _00444_ VSS VSS VDD VDD _00445_ _00446_
+ sky130_fd_sc_hd__fa_1
X_09884_ net459 _00447_ _00448_ VSS VSS VDD VDD _05152_ _05153_
+ sky130_fd_sc_hd__fa_1
X_09885_ _00449_ _05149_ _00450_ VSS VSS VDD VDD _00451_ _00452_
+ sky130_fd_sc_hd__fa_1
X_09886_ net431 _05154_ _00455_ VSS VSS VDD VDD _00456_ _00457_
+ sky130_fd_sc_hd__fa_1
X_09887_ net430 _00458_ _00459_ VSS VSS VDD VDD _00460_ _00461_
+ sky130_fd_sc_hd__fa_1
X_09888_ net459 _05155_ _05156_ VSS VSS VDD VDD _00462_ _00463_
+ sky130_fd_sc_hd__fa_1
X_09889_ net429 _00464_ _00465_ VSS VSS VDD VDD _00466_ _00467_
+ sky130_fd_sc_hd__fa_1
X_09890_ net431 _05157_ _00468_ VSS VSS VDD VDD _00469_ _00470_
+ sky130_fd_sc_hd__fa_1
X_09891_ net430 _00471_ _00472_ VSS VSS VDD VDD _00473_ _00474_
+ sky130_fd_sc_hd__fa_1
X_09892_ net459 _05158_ _05159_ VSS VSS VDD VDD _00475_ _00476_
+ sky130_fd_sc_hd__fa_1
X_09893_ net429 _00477_ _00478_ VSS VSS VDD VDD _00479_ _00480_
+ sky130_fd_sc_hd__fa_1
X_09894_ net430 _00481_ _00482_ VSS VSS VDD VDD _00483_ _00484_
+ sky130_fd_sc_hd__fa_1
X_09895_ net459 _05160_ _05161_ VSS VSS VDD VDD _00485_ _00486_
+ sky130_fd_sc_hd__fa_1
X_09896_ net429 _00487_ _00488_ VSS VSS VDD VDD _00489_ _00490_
+ sky130_fd_sc_hd__fa_1
X_09897_ net430 _00491_ _00492_ VSS VSS VDD VDD _00493_ _00494_
+ sky130_fd_sc_hd__fa_1
X_09898_ net429 _00495_ _00496_ VSS VSS VDD VDD _00497_ _00498_
+ sky130_fd_sc_hd__fa_1
X_09899_ net430 _00499_ _00500_ VSS VSS VDD VDD _00501_ _00502_
+ sky130_fd_sc_hd__fa_1
X_09900_ net429 _00503_ _00504_ VSS VSS VDD VDD _00505_ _00506_
+ sky130_fd_sc_hd__fa_1
X_09901_ _05162_ _00507_ _05163_ VSS VSS VDD VDD _05164_ _00508_
+ sky130_fd_sc_hd__fa_1
X_09902_ _00509_ _00510_ _00511_ VSS VSS VDD VDD _05165_ _05166_
+ sky130_fd_sc_hd__fa_1
X_09903_ _00512_ _05167_ _00513_ VSS VSS VDD VDD _00514_ _05168_
+ sky130_fd_sc_hd__fa_1
X_09904_ _00515_ _05169_ _05166_ VSS VSS VDD VDD _05170_ _00516_
+ sky130_fd_sc_hd__fa_1
X_09905_ _05168_ _00517_ _00518_ VSS VSS VDD VDD _05169_ _00519_
+ sky130_fd_sc_hd__fa_1
X_09906_ _05171_ _00520_ _05172_ VSS VSS VDD VDD _05173_ _05174_
+ sky130_fd_sc_hd__fa_1
X_09907_ _05175_ _05176_ _00521_ VSS VSS VDD VDD _05177_ _05178_
+ sky130_fd_sc_hd__fa_1
X_09908_ _05179_ _05180_ _00522_ VSS VSS VDD VDD _05176_ _05181_
+ sky130_fd_sc_hd__fa_1
X_09909_ _05182_ _00523_ _00524_ VSS VSS VDD VDD _05183_ _05184_
+ sky130_fd_sc_hd__fa_1
X_09910_ _05185_ _05186_ _05181_ VSS VSS VDD VDD _05187_ _05188_
+ sky130_fd_sc_hd__fa_1
X_09911_ _05189_ _05190_ _05191_ VSS VSS VDD VDD _05186_ _05192_
+ sky130_fd_sc_hd__fa_1
X_09912_ _05193_ _05194_ _05192_ VSS VSS VDD VDD _05195_ _05196_
+ sky130_fd_sc_hd__fa_1
X_09913_ _05197_ _05198_ _05199_ VSS VSS VDD VDD _05194_ _05200_
+ sky130_fd_sc_hd__fa_1
X_09914_ _05201_ _00525_ _05200_ VSS VSS VDD VDD _05202_ _05203_
+ sky130_fd_sc_hd__fa_1
X_09915_ _00526_ _00527_ _00528_ VSS VSS VDD VDD _00529_ _05204_
+ sky130_fd_sc_hd__fa_1
X_09916_ _00530_ _00531_ _05204_ VSS VSS VDD VDD _00532_ _00533_
+ sky130_fd_sc_hd__fa_1
X_09917_ _00534_ _00535_ _00536_ VSS VSS VDD VDD _00537_ _00538_
+ sky130_fd_sc_hd__fa_1
X_09918_ _05205_ _00539_ _05206_ VSS VSS VDD VDD _05207_ _00540_
+ sky130_fd_sc_hd__fa_1
X_09919_ _00541_ _00542_ _00543_ VSS VSS VDD VDD _05208_ _05209_
+ sky130_fd_sc_hd__fa_1
X_09920_ _00544_ _05165_ _05209_ VSS VSS VDD VDD _05210_ _05211_
+ sky130_fd_sc_hd__fa_1
X_09921_ _00545_ _05170_ _05211_ VSS VSS VDD VDD _00546_ _00547_
+ sky130_fd_sc_hd__fa_1
X_09922_ _05212_ _00549_ _05213_ VSS VSS VDD VDD _05214_ _05215_
+ sky130_fd_sc_hd__fa_1
X_09923_ _05215_ _05216_ _05217_ VSS VSS VDD VDD _00550_ _00551_
+ sky130_fd_sc_hd__fa_1
X_09924_ _00552_ _05208_ _00553_ VSS VSS VDD VDD _05218_ _05219_
+ sky130_fd_sc_hd__fa_1
X_09925_ _00554_ _05210_ _05219_ VSS VSS VDD VDD _00555_ _00556_
+ sky130_fd_sc_hd__fa_1
X_09926_ _05220_ _00558_ _05221_ VSS VSS VDD VDD _05222_ _05223_
+ sky130_fd_sc_hd__fa_1
X_09927_ _05223_ _05224_ _05225_ VSS VSS VDD VDD _00559_ _00560_
+ sky130_fd_sc_hd__fa_1
X_09928_ _00561_ _00562_ _00563_ VSS VSS VDD VDD _00564_ _05226_
+ sky130_fd_sc_hd__fa_1
X_09929_ _00565_ _05218_ _05226_ VSS VSS VDD VDD _00566_ _00567_
+ sky130_fd_sc_hd__fa_1
X_09930_ _05227_ _00569_ _05228_ VSS VSS VDD VDD _05229_ _05230_
+ sky130_fd_sc_hd__fa_1
X_09931_ _05230_ _05231_ _05232_ VSS VSS VDD VDD _00570_ _00571_
+ sky130_fd_sc_hd__fa_1
X_09932_ _00572_ _00573_ _00574_ VSS VSS VDD VDD _00575_ _00576_
+ sky130_fd_sc_hd__fa_1
X_09933_ _05233_ _00577_ _00578_ VSS VSS VDD VDD _05234_ _05235_
+ sky130_fd_sc_hd__fa_1
X_09934_ _05236_ _00579_ _05237_ VSS VSS VDD VDD _05238_ _05239_
+ sky130_fd_sc_hd__fa_1
X_09935_ _05239_ _05240_ _05241_ VSS VSS VDD VDD _00580_ _00581_
+ sky130_fd_sc_hd__fa_1
X_09936_ _00582_ _00583_ _00584_ VSS VSS VDD VDD _00585_ _00586_
+ sky130_fd_sc_hd__fa_1
X_09937_ _05242_ _00587_ _00588_ VSS VSS VDD VDD _05243_ _05244_
+ sky130_fd_sc_hd__fa_1
X_09938_ _00589_ _00590_ _00591_ VSS VSS VDD VDD _00592_ _00593_
+ sky130_fd_sc_hd__fa_1
X_09939_ _00594_ _05245_ _05246_ VSS VSS VDD VDD _00595_ _00596_
+ sky130_fd_sc_hd__fa_1
X_09940_ _00597_ _00598_ _00599_ VSS VSS VDD VDD _00600_ _00601_
+ sky130_fd_sc_hd__fa_1
X_09941_ _05247_ _00602_ _00603_ VSS VSS VDD VDD _05248_ _05249_
+ sky130_fd_sc_hd__fa_1
X_09942_ _05250_ _05251_ _05252_ VSS VSS VDD VDD _00604_ _00605_
+ sky130_fd_sc_hd__fa_1
X_09943_ _00606_ _00607_ _00608_ VSS VSS VDD VDD _00609_ _00610_
+ sky130_fd_sc_hd__fa_1
X_09944_ _05253_ _00611_ _00612_ VSS VSS VDD VDD _05254_ _05255_
+ sky130_fd_sc_hd__fa_1
X_09945_ _00613_ _05256_ _05257_ VSS VSS VDD VDD _00614_ _00615_
+ sky130_fd_sc_hd__fa_1
X_09946_ _00616_ _00617_ _00618_ VSS VSS VDD VDD _00619_ _00620_
+ sky130_fd_sc_hd__fa_1
X_09947_ _05258_ _00621_ _00622_ VSS VSS VDD VDD _05259_ _05260_
+ sky130_fd_sc_hd__fa_1
X_09948_ _05261_ _05262_ _05263_ VSS VSS VDD VDD _00623_ _00624_
+ sky130_fd_sc_hd__fa_1
X_09949_ _00625_ _00626_ _00627_ VSS VSS VDD VDD _00628_ _00629_
+ sky130_fd_sc_hd__fa_1
X_09950_ _05264_ _00630_ _00631_ VSS VSS VDD VDD _05265_ _05266_
+ sky130_fd_sc_hd__fa_1
X_09951_ _00632_ _00633_ _00634_ VSS VSS VDD VDD _00635_ _05267_
+ sky130_fd_sc_hd__fa_1
X_09952_ _00636_ _00637_ _05267_ VSS VSS VDD VDD _00638_ _00639_
+ sky130_fd_sc_hd__fa_1
X_09953_ _05268_ _00640_ _00641_ VSS VSS VDD VDD _05269_ _05270_
+ sky130_fd_sc_hd__fa_1
X_09954_ stage3_in_r\[77\] _00642_ _00643_ VSS VSS VDD VDD
+ _00644_ _05271_ sky130_fd_sc_hd__fa_1
X_09955_ _05272_ _00645_ _05271_ VSS VSS VDD VDD _05273_ _05274_
+ sky130_fd_sc_hd__fa_1
X_09956_ net427 _00647_ _00648_ VSS VSS VDD VDD _00649_ _00650_
+ sky130_fd_sc_hd__fa_1
X_09957_ _00394_ _05275_ _05276_ VSS VSS VDD VDD _05277_ _00651_
+ sky130_fd_sc_hd__fa_1
X_09958_ _00652_ _00653_ _00654_ VSS VSS VDD VDD _05278_ _05279_
+ sky130_fd_sc_hd__fa_1
X_09959_ _05120_ _00655_ _00656_ VSS VSS VDD VDD _00657_ _05280_
+ sky130_fd_sc_hd__fa_1
X_09960_ _00658_ _05281_ _05279_ VSS VSS VDD VDD _05282_ _00659_
+ sky130_fd_sc_hd__fa_1
X_09961_ _05280_ _00660_ _00661_ VSS VSS VDD VDD _05281_ _00662_
+ sky130_fd_sc_hd__fa_1
X_09962_ _05283_ _05284_ _00663_ VSS VSS VDD VDD _05285_ _05286_
+ sky130_fd_sc_hd__fa_1
X_09963_ _05287_ _05288_ _00664_ VSS VSS VDD VDD _05289_ _05290_
+ sky130_fd_sc_hd__fa_1
X_09964_ _05291_ _05292_ _00665_ VSS VSS VDD VDD _05288_ _05293_
+ sky130_fd_sc_hd__fa_1
X_09965_ _05092_ _00666_ _00667_ VSS VSS VDD VDD _00668_ _00669_
+ sky130_fd_sc_hd__fa_1
X_09966_ _05294_ _05295_ _05293_ VSS VSS VDD VDD _05296_ _05297_
+ sky130_fd_sc_hd__fa_1
X_09967_ _05298_ _05299_ _05300_ VSS VSS VDD VDD _05295_ _05301_
+ sky130_fd_sc_hd__fa_1
X_09968_ _05302_ _05303_ _05301_ VSS VSS VDD VDD _05304_ _05305_
+ sky130_fd_sc_hd__fa_1
X_09969_ _05306_ _05307_ _05308_ VSS VSS VDD VDD _05303_ _05309_
+ sky130_fd_sc_hd__fa_1
X_09970_ _05310_ _00670_ _05309_ VSS VSS VDD VDD _05311_ _05312_
+ sky130_fd_sc_hd__fa_1
X_09971_ _00671_ _00672_ _00673_ VSS VSS VDD VDD _00674_ _05313_
+ sky130_fd_sc_hd__fa_1
X_09972_ _00675_ _00676_ _05313_ VSS VSS VDD VDD _00677_ _00678_
+ sky130_fd_sc_hd__fa_1
X_09973_ _00679_ net451 _00680_ VSS VSS VDD VDD _05314_ _00681_
+ sky130_fd_sc_hd__fa_1
X_09974_ _00682_ _00683_ _00684_ VSS VSS VDD VDD _05315_ _05316_
+ sky130_fd_sc_hd__fa_1
X_09975_ net449 net448 stage3_in_r\[76\] VSS VSS VDD VDD _05317_
+ _05318_ sky130_fd_sc_hd__fa_1
X_09976_ _00685_ _05318_ _00686_ VSS VSS VDD VDD _00687_ _05319_
+ sky130_fd_sc_hd__fa_1
X_09977_ net448 stage3_in_r\[76\] stage3_in_r\[77\] VSS VSS
+ VDD VDD _00688_ _00689_ sky130_fd_sc_hd__fa_1
X_09978_ _00690_ _05320_ _05316_ VSS VSS VDD VDD _05321_ _05322_
+ sky130_fd_sc_hd__fa_1
X_09979_ _00691_ _00692_ _00693_ VSS VSS VDD VDD _05320_ _00694_
+ sky130_fd_sc_hd__fa_1
X_09980_ _00695_ _00696_ _00697_ VSS VSS VDD VDD _00698_ _00699_
+ sky130_fd_sc_hd__fa_1
X_09981_ _00702_ _00703_ _00704_ VSS VSS VDD VDD _00696_ _00705_
+ sky130_fd_sc_hd__fa_1
X_09982_ _00706_ _00707_ _05322_ VSS VSS VDD VDD _05323_ _05324_
+ sky130_fd_sc_hd__fa_1
X_09983_ _05325_ _00708_ _00709_ VSS VSS VDD VDD _00710_ _05326_
+ sky130_fd_sc_hd__fa_1
X_09984_ _00711_ _00712_ _00713_ VSS VSS VDD VDD _00714_ _00715_
+ sky130_fd_sc_hd__fa_1
X_09985_ _00716_ _00717_ _00689_ VSS VSS VDD VDD _05327_ _05328_
+ sky130_fd_sc_hd__fa_1
X_09986_ _00719_ _00702_ _00703_ VSS VSS VDD VDD _00718_ _00720_
+ sky130_fd_sc_hd__fa_1
X_09987_ net427 _00721_ _00722_ VSS VSS VDD VDD _05329_ _00723_
+ sky130_fd_sc_hd__fa_1
X_09988_ _05329_ _00724_ _05324_ VSS VSS VDD VDD _00725_ _00726_
+ sky130_fd_sc_hd__fa_1
X_09989_ _00727_ _05330_ _05326_ VSS VSS VDD VDD _00728_ _00729_
+ sky130_fd_sc_hd__fa_1
X_09990_ _05331_ _05332_ _00730_ VSS VSS VDD VDD _05330_ _05333_
+ sky130_fd_sc_hd__fa_1
X_09991_ _00731_ _00732_ _05318_ VSS VSS VDD VDD _05334_ _05335_
+ sky130_fd_sc_hd__fa_1
X_09992_ _00711_ _00719_ _00702_ VSS VSS VDD VDD _00733_ _00734_
+ sky130_fd_sc_hd__fa_1
X_09993_ _00703_ _00704_ _00735_ VSS VSS VDD VDD _00736_ _00737_
+ sky130_fd_sc_hd__fa_1
X_09994_ _00738_ _00739_ _00740_ VSS VSS VDD VDD _00741_ _00742_
+ sky130_fd_sc_hd__fa_1
X_09995_ _05336_ _05337_ _05333_ VSS VSS VDD VDD _00743_ _00744_
+ sky130_fd_sc_hd__fa_1
X_09996_ _05338_ _05339_ _05340_ VSS VSS VDD VDD _05337_ _05341_
+ sky130_fd_sc_hd__fa_1
X_09997_ _00745_ _00746_ _00747_ VSS VSS VDD VDD _05342_ _05343_
+ sky130_fd_sc_hd__fa_1
X_09998_ _00748_ _00711_ _00719_ VSS VSS VDD VDD _00749_ _00750_
+ sky130_fd_sc_hd__fa_1
X_09999_ _00751_ _00752_ _00753_ VSS VSS VDD VDD _00754_ _00755_
+ sky130_fd_sc_hd__fa_1
X_10000_ _05344_ _00756_ _05341_ VSS VSS VDD VDD _00757_ _05345_
+ sky130_fd_sc_hd__fa_1
X_10001_ _00758_ _00759_ _00760_ VSS VSS VDD VDD _00761_ _00762_
+ sky130_fd_sc_hd__fa_1
X_10002_ _00763_ _00764_ _00717_ VSS VSS VDD VDD _05346_ _05347_
+ sky130_fd_sc_hd__fa_1
X_10003_ _00765_ _00748_ _00711_ VSS VSS VDD VDD _00766_ _00767_
+ sky130_fd_sc_hd__fa_1
X_10004_ _05348_ _05349_ _05345_ VSS VSS VDD VDD _05350_ _05351_
+ sky130_fd_sc_hd__fa_1
X_10005_ _05352_ _00768_ _00769_ VSS VSS VDD VDD _05349_ _00770_
+ sky130_fd_sc_hd__fa_1
X_10006_ _00771_ _00684_ _00680_ VSS VSS VDD VDD _00772_ _00773_
+ sky130_fd_sc_hd__fa_1
X_10007_ _00774_ _00775_ _00732_ VSS VSS VDD VDD _05353_ _05354_
+ sky130_fd_sc_hd__fa_1
X_10008_ _00776_ _00765_ _00748_ VSS VSS VDD VDD _00777_ _00778_
+ sky130_fd_sc_hd__fa_1
X_10009_ _00779_ _00780_ _00781_ VSS VSS VDD VDD _00782_ _00783_
+ sky130_fd_sc_hd__fa_1
X_10010_ _05355_ _05356_ _00784_ VSS VSS VDD VDD _00785_ _05357_
+ sky130_fd_sc_hd__fa_1
X_10011_ _05358_ _00786_ _00747_ VSS VSS VDD VDD _05359_ _05360_
+ sky130_fd_sc_hd__fa_1
X_10012_ stage3_in_r\[66\] net454 net453 VSS VSS VDD VDD _05358_
+ _00787_ sky130_fd_sc_hd__fa_1
X_10013_ _05361_ _05362_ _05357_ VSS VSS VDD VDD _05363_ _05364_
+ sky130_fd_sc_hd__fa_1
X_10014_ _05365_ _05366_ _05367_ VSS VSS VDD VDD _05362_ _05368_
+ sky130_fd_sc_hd__fa_1
X_10015_ _00788_ _00789_ _00750_ VSS VSS VDD VDD _00790_ _00791_
+ sky130_fd_sc_hd__fa_1
X_10016_ stage3_in_r\[65\] stage3_in_r\[66\] net454 VSS VSS
+ VDD VDD _00792_ _05369_ sky130_fd_sc_hd__fa_1
X_10017_ _05370_ _00793_ _05368_ VSS VSS VDD VDD _05371_ _05372_
+ sky130_fd_sc_hd__fa_1
X_10018_ _00794_ _00795_ _00796_ VSS VSS VDD VDD _00797_ _00798_
+ sky130_fd_sc_hd__fa_1
X_10019_ stage3_in_r\[64\] stage3_in_r\[65\] stage3_in_r\[66\]
+ VSS VSS VDD VDD _05373_ _00799_ sky130_fd_sc_hd__fa_1
X_10020_ _05373_ _05369_ _00775_ VSS VSS VDD VDD _05374_ _05375_
+ sky130_fd_sc_hd__fa_1
X_10021_ _05376_ _05377_ _00800_ VSS VSS VDD VDD _05378_ _05379_
+ sky130_fd_sc_hd__fa_1
X_10022_ _00801_ _00778_ _00802_ VSS VSS VDD VDD _00803_ _00804_
+ sky130_fd_sc_hd__fa_1
X_10023_ _00805_ _00806_ _00807_ VSS VSS VDD VDD _00808_ _00809_
+ sky130_fd_sc_hd__fa_1
X_10024_ _00810_ _00811_ _00812_ VSS VSS VDD VDD _00813_ _00814_
+ sky130_fd_sc_hd__fa_1
X_10025_ _00815_ _00816_ _00817_ VSS VSS VDD VDD _00818_ _00819_
+ sky130_fd_sc_hd__fa_1
X_10026_ _00820_ _00821_ _00822_ VSS VSS VDD VDD _00823_ _05380_
+ sky130_fd_sc_hd__fa_1
X_10027_ _00415_ _05381_ _05382_ VSS VSS VDD VDD _05383_ _00824_
+ sky130_fd_sc_hd__fa_1
X_10028_ _00825_ _00826_ _00827_ VSS VSS VDD VDD _05384_ _05385_
+ sky130_fd_sc_hd__fa_1
X_10029_ _00828_ _05278_ _05385_ VSS VSS VDD VDD _05386_ _05387_
+ sky130_fd_sc_hd__fa_1
X_10030_ _00829_ _05282_ _05387_ VSS VSS VDD VDD _00830_ _00831_
+ sky130_fd_sc_hd__fa_1
X_10031_ stage3_in_r\[71\] _00760_ _05388_ VSS VSS VDD VDD
+ _05389_ _05390_ sky130_fd_sc_hd__fa_1
X_10032_ net450 _05314_ _05390_ VSS VSS VDD VDD _00833_ _00834_
+ sky130_fd_sc_hd__fa_1
X_10033_ net447 _05317_ _00689_ VSS VSS VDD VDD _00835_ _00836_
+ sky130_fd_sc_hd__fa_1
X_10034_ _00837_ _00838_ _00839_ VSS VSS VDD VDD _00840_ _05391_
+ sky130_fd_sc_hd__fa_1
X_10035_ _05391_ _05315_ _00841_ VSS VSS VDD VDD _05392_ _05393_
+ sky130_fd_sc_hd__fa_1
X_10036_ _00842_ _05321_ _05393_ VSS VSS VDD VDD _05394_ _05395_
+ sky130_fd_sc_hd__fa_1
X_10037_ _00843_ _05323_ _05395_ VSS VSS VDD VDD _00844_ _00845_
+ sky130_fd_sc_hd__fa_1
X_10038_ _00847_ _05396_ _05397_ VSS VSS VDD VDD _05398_ _05399_
+ sky130_fd_sc_hd__fa_1
X_10039_ _05399_ _05400_ _05401_ VSS VSS VDD VDD _00848_ _00849_
+ sky130_fd_sc_hd__fa_1
X_10040_ _00850_ _05384_ _00851_ VSS VSS VDD VDD _05402_ _05403_
+ sky130_fd_sc_hd__fa_1
X_10041_ _00852_ _05386_ _05403_ VSS VSS VDD VDD _00853_ _00854_
+ sky130_fd_sc_hd__fa_1
X_10042_ stage3_in_r\[72\] _00856_ _05404_ VSS VSS VDD VDD
+ _05405_ _05406_ sky130_fd_sc_hd__fa_1
X_10043_ net449 _05389_ _05406_ VSS VSS VDD VDD _00857_ _00858_
+ sky130_fd_sc_hd__fa_1
X_10044_ _00632_ _00859_ net427 VSS VSS VDD VDD _00860_ _00861_
+ sky130_fd_sc_hd__fa_1
X_10045_ _00632_ stage3_in_r\[77\] net447 VSS VSS VDD VDD
+ _05407_ _05408_ sky130_fd_sc_hd__fa_1
X_10046_ _00862_ _00863_ _00864_ VSS VSS VDD VDD _05409_ _05410_
+ sky130_fd_sc_hd__fa_1
X_10047_ _00865_ _05392_ _05410_ VSS VSS VDD VDD _05411_ _05412_
+ sky130_fd_sc_hd__fa_1
X_10048_ _00866_ _05394_ _05412_ VSS VSS VDD VDD _00867_ _00868_
+ sky130_fd_sc_hd__fa_1
X_10049_ _00870_ _05413_ _05414_ VSS VSS VDD VDD _05415_ _05416_
+ sky130_fd_sc_hd__fa_1
X_10050_ _05416_ _05417_ _05418_ VSS VSS VDD VDD _00871_ _00872_
+ sky130_fd_sc_hd__fa_1
X_10051_ _00873_ _00874_ _00875_ VSS VSS VDD VDD _00876_ _05419_
+ sky130_fd_sc_hd__fa_1
X_10052_ _00877_ _05402_ _05419_ VSS VSS VDD VDD _00878_ _00879_
+ sky130_fd_sc_hd__fa_1
X_10053_ net450 _00881_ _05420_ VSS VSS VDD VDD _05421_ _05422_
+ sky130_fd_sc_hd__fa_1
X_10054_ net448 _05405_ _05422_ VSS VSS VDD VDD _00882_ _00883_
+ sky130_fd_sc_hd__fa_1
X_10055_ _00884_ _00885_ _00886_ VSS VSS VDD VDD _05423_ _05424_
+ sky130_fd_sc_hd__fa_1
X_10056_ _00887_ _05409_ _05424_ VSS VSS VDD VDD _05425_ _05426_
+ sky130_fd_sc_hd__fa_1
X_10057_ _00888_ _05411_ _05426_ VSS VSS VDD VDD _00889_ _00890_
+ sky130_fd_sc_hd__fa_1
X_10058_ _00892_ _05427_ _05428_ VSS VSS VDD VDD _05429_ _05430_
+ sky130_fd_sc_hd__fa_1
X_10059_ _05430_ _05431_ _05432_ VSS VSS VDD VDD _00893_ _00894_
+ sky130_fd_sc_hd__fa_1
X_10060_ _00895_ _00896_ _00897_ VSS VSS VDD VDD _00898_ _00899_
+ sky130_fd_sc_hd__fa_1
X_10061_ _05433_ _00900_ _00901_ VSS VSS VDD VDD _05434_ _05435_
+ sky130_fd_sc_hd__fa_1
X_10062_ net449 _00693_ _05436_ VSS VSS VDD VDD _00902_ _05437_
+ sky130_fd_sc_hd__fa_1
X_10063_ stage3_in_r\[76\] _05421_ _05437_ VSS VSS VDD VDD
+ _00903_ _00904_ sky130_fd_sc_hd__fa_1
X_10064_ _00905_ _00906_ _00907_ VSS VSS VDD VDD _05438_ _05439_
+ sky130_fd_sc_hd__fa_1
X_10065_ _00908_ _05423_ _05439_ VSS VSS VDD VDD _05440_ _05441_
+ sky130_fd_sc_hd__fa_1
X_10066_ _00909_ _05425_ _05441_ VSS VSS VDD VDD _00910_ _00911_
+ sky130_fd_sc_hd__fa_1
X_10067_ _00912_ _05442_ _05443_ VSS VSS VDD VDD _05444_ _05445_
+ sky130_fd_sc_hd__fa_1
X_10068_ _05445_ _05446_ _05447_ VSS VSS VDD VDD _00913_ _00914_
+ sky130_fd_sc_hd__fa_1
X_10069_ _00915_ _00916_ _00917_ VSS VSS VDD VDD _00918_ _00919_
+ sky130_fd_sc_hd__fa_1
X_10070_ _05448_ _00920_ _00921_ VSS VSS VDD VDD _05449_ _05450_
+ sky130_fd_sc_hd__fa_1
X_10071_ net448 _05167_ _05451_ VSS VSS VDD VDD _00922_ _00923_
+ sky130_fd_sc_hd__fa_1
X_10072_ _00859_ _00924_ _00925_ VSS VSS VDD VDD _00926_ _05452_
+ sky130_fd_sc_hd__fa_1
X_10073_ _00927_ _00928_ _05452_ VSS VSS VDD VDD _05453_ _05454_
+ sky130_fd_sc_hd__fa_1
X_10074_ _00929_ _05438_ _05454_ VSS VSS VDD VDD _05455_ _05456_
+ sky130_fd_sc_hd__fa_1
X_10075_ _00930_ _05440_ _05456_ VSS VSS VDD VDD _00931_ _00932_
+ sky130_fd_sc_hd__fa_1
X_10076_ _00933_ net426 _00009_ VSS VSS VDD VDD _00935_ _00936_
+ sky130_fd_sc_hd__fa_1
X_10077_ _00937_ _05457_ _05458_ VSS VSS VDD VDD _00938_ _00939_
+ sky130_fd_sc_hd__fa_1
X_10078_ _00940_ _00941_ _00942_ VSS VSS VDD VDD _00943_ _00944_
+ sky130_fd_sc_hd__fa_1
X_10079_ _05459_ _00945_ _00946_ VSS VSS VDD VDD _05460_ _05461_
+ sky130_fd_sc_hd__fa_1
X_10080_ _00632_ _00507_ _00947_ VSS VSS VDD VDD _00948_ _05462_
+ sky130_fd_sc_hd__fa_1
X_10081_ net427 _00949_ _05462_ VSS VSS VDD VDD _00950_ _00951_
+ sky130_fd_sc_hd__fa_1
X_10082_ _00952_ _05453_ _00953_ VSS VSS VDD VDD _05463_ _05464_
+ sky130_fd_sc_hd__fa_1
X_10083_ _00954_ _05455_ _05464_ VSS VSS VDD VDD _00955_ _00956_
+ sky130_fd_sc_hd__fa_1
X_10084_ _05465_ _05466_ _05467_ VSS VSS VDD VDD _00957_ _00958_
+ sky130_fd_sc_hd__fa_1
X_10085_ _00959_ _00960_ _00961_ VSS VSS VDD VDD _00962_ _00963_
+ sky130_fd_sc_hd__fa_1
X_10086_ _05468_ _00964_ _00965_ VSS VSS VDD VDD _05469_ _05470_
+ sky130_fd_sc_hd__fa_1
X_10087_ _00859_ _00539_ _00966_ VSS VSS VDD VDD _00967_ _00968_
+ sky130_fd_sc_hd__fa_1
X_10088_ net447 _00969_ _00970_ VSS VSS VDD VDD _05471_ _05472_
+ sky130_fd_sc_hd__fa_1
X_10089_ _00971_ _05463_ _00972_ VSS VSS VDD VDD _00973_ _00974_
+ sky130_fd_sc_hd__fa_1
X_10090_ _00977_ _05473_ _05474_ VSS VSS VDD VDD _00978_ _00979_
+ sky130_fd_sc_hd__fa_1
X_10091_ _00980_ _00981_ _00982_ VSS VSS VDD VDD _00983_ _00984_
+ sky130_fd_sc_hd__fa_1
X_10092_ _05475_ _00985_ _00986_ VSS VSS VDD VDD _05476_ _05477_
+ sky130_fd_sc_hd__fa_1
X_10093_ net447 _00987_ _05478_ VSS VSS VDD VDD _00988_ _00989_
+ sky130_fd_sc_hd__fa_1
X_10094_ net427 _00990_ _00991_ VSS VSS VDD VDD _00992_ _00993_
+ sky130_fd_sc_hd__fa_1
X_10095_ _05479_ _05480_ _05481_ VSS VSS VDD VDD _00994_ _00995_
+ sky130_fd_sc_hd__fa_1
X_10096_ _00996_ _00997_ _00998_ VSS VSS VDD VDD _00999_ _01000_
+ sky130_fd_sc_hd__fa_1
X_10097_ _05482_ _01001_ _01002_ VSS VSS VDD VDD _05483_ _05484_
+ sky130_fd_sc_hd__fa_1
X_10098_ net447 _01003_ _05485_ VSS VSS VDD VDD _01004_ _01005_
+ sky130_fd_sc_hd__fa_1
X_10099_ net427 _01006_ _01007_ VSS VSS VDD VDD _01008_ _01009_
+ sky130_fd_sc_hd__fa_1
X_10100_ _00308_ _01010_ _01011_ VSS VSS VDD VDD _01012_ _05486_
+ sky130_fd_sc_hd__fa_1
X_10101_ _01013_ _01014_ _05486_ VSS VSS VDD VDD _01015_ _01016_
+ sky130_fd_sc_hd__fa_1
X_10102_ _05487_ _01017_ _01018_ VSS VSS VDD VDD _05488_ _05489_
+ sky130_fd_sc_hd__fa_1
X_10103_ net447 _01019_ _05490_ VSS VSS VDD VDD _01020_ _01021_
+ sky130_fd_sc_hd__fa_1
X_10104_ net427 _01022_ _01023_ VSS VSS VDD VDD _01024_ _01025_
+ sky130_fd_sc_hd__fa_1
X_10105_ net433 _01026_ _01027_ VSS VSS VDD VDD _01028_ _05491_
+ sky130_fd_sc_hd__fa_1
X_10106_ _05492_ _01029_ _05491_ VSS VSS VDD VDD _05493_ _05494_
+ sky130_fd_sc_hd__fa_1
X_10107_ net427 _01030_ _01031_ VSS VSS VDD VDD _01032_ _01033_
+ sky130_fd_sc_hd__fa_1
X_10108_ net430 _01034_ _01035_ VSS VSS VDD VDD _01036_ _01037_
+ sky130_fd_sc_hd__fa_1
X_10109_ _01038_ net427 _01039_ VSS VSS VDD VDD _01040_ _01041_
+ sky130_fd_sc_hd__fa_1
X_10110_ net427 _01042_ _01043_ VSS VSS VDD VDD _01044_ _01045_
+ sky130_fd_sc_hd__fa_1
X_10111_ _01046_ _01047_ _01048_ VSS VSS VDD VDD _01049_ _01050_
+ sky130_fd_sc_hd__fa_1
X_10112_ stage1_in_r\[145\] _01051_ _01052_ VSS VSS VDD VDD
+ _01053_ _01054_ sky130_fd_sc_hd__fa_1
X_10113_ _01055_ _01051_ _01056_ VSS VSS VDD VDD _01057_ _01058_
+ sky130_fd_sc_hd__fa_1
X_10114_ _01059_ _01060_ _01061_ VSS VSS VDD VDD _01062_ _01063_
+ sky130_fd_sc_hd__fa_1
X_10115_ stage1_in_r\[17\] _01064_ _01065_ VSS VSS VDD VDD
+ _01066_ _01067_ sky130_fd_sc_hd__fa_1
X_10116_ _01068_ _01064_ _01069_ VSS VSS VDD VDD _01070_ _01071_
+ sky130_fd_sc_hd__fa_1
X_10117_ _01072_ _01073_ _01074_ VSS VSS VDD VDD _01075_ _01076_
+ sky130_fd_sc_hd__fa_1
X_10118_ stage2_in_r\[49\] _01077_ _01078_ VSS VSS VDD VDD
+ _01079_ _01080_ sky130_fd_sc_hd__fa_1
X_10119_ _01081_ _01077_ _01082_ VSS VSS VDD VDD _01083_ _01084_
+ sky130_fd_sc_hd__fa_1
X_10120_ stage3_in_r\[113\] _01085_ _01086_ VSS VSS VDD VDD
+ _01087_ _01088_ sky130_fd_sc_hd__fa_1
X_10121_ _01089_ _01085_ _01090_ VSS VSS VDD VDD _01091_ _01092_
+ sky130_fd_sc_hd__fa_1
X_10122_ _01093_ _01094_ _01095_ VSS VSS VDD VDD _01096_ _01097_
+ sky130_fd_sc_hd__fa_1
X_10123_ _01098_ _01099_ _01100_ VSS VSS VDD VDD _01101_ _01102_
+ sky130_fd_sc_hd__fa_1
X_10124_ _01093_ _01103_ _01104_ VSS VSS VDD VDD _01105_ _01106_
+ sky130_fd_sc_hd__fa_1
X_10125_ _01098_ _01107_ _01108_ VSS VSS VDD VDD _01109_ _01110_
+ sky130_fd_sc_hd__fa_1
X_10126_ _01111_ _01112_ _01113_ VSS VSS VDD VDD _01114_ _01115_
+ sky130_fd_sc_hd__fa_1
X_10127_ _01098_ _01117_ _01118_ VSS VSS VDD VDD _01119_ _01120_
+ sky130_fd_sc_hd__fa_1
X_10128_ stage3_in_r\[129\] _01122_ _01113_ VSS VSS VDD VDD
+ _01123_ stage3_out\[128\] sky130_fd_sc_hd__fa_1
X_10129_ stage3_in_r\[145\] _01124_ _01118_ VSS VSS VDD VDD
+ _01125_ stage3_out\[144\] sky130_fd_sc_hd__fa_1
X_10130_ _01126_ _01127_ VSS VSS VDD VDD _01128_ stage3_out\[160\]
+ sky130_fd_sc_hd__ha_1
X_10131_ net438 _01129_ VSS VSS VDD VDD _01130_ _04915_ sky130_fd_sc_hd__ha_1
X_10132_ net445 net444 VSS VSS VDD VDD _00002_ _01131_ sky130_fd_sc_hd__ha_1
X_10133_ net436 net435 VSS VSS VDD VDD _05495_ _05496_ sky130_fd_sc_hd__ha_1
X_10134_ net437 net436 VSS VSS VDD VDD _00007_ _00024_ sky130_fd_sc_hd__ha_1
X_10135_ net438 net437 VSS VSS VDD VDD _05443_ _05497_ sky130_fd_sc_hd__ha_1
X_10136_ net435 net434 VSS VSS VDD VDD _01133_ _05498_ sky130_fd_sc_hd__ha_1
X_10137_ _01134_ _04918_ VSS VSS VDD VDD _05499_ _01135_ sky130_fd_sc_hd__ha_1
X_10138_ stage3_in_r\[17\] net442 VSS VSS VDD VDD _01132_
+ _01136_ sky130_fd_sc_hd__ha_1
X_10139_ net439 net438 VSS VSS VDD VDD _05428_ _05500_ sky130_fd_sc_hd__ha_1
X_10140_ _04926_ _01138_ VSS VSS VDD VDD _05501_ _04924_ sky130_fd_sc_hd__ha_1
X_10141_ _00010_ _05501_ VSS VSS VDD VDD _00288_ _01139_ sky130_fd_sc_hd__ha_1
X_10142_ net445 net443 VSS VSS VDD VDD _01137_ _05502_ sky130_fd_sc_hd__ha_1
X_10143_ net440 net439 VSS VSS VDD VDD _05414_ _05503_ sky130_fd_sc_hd__ha_1
X_10144_ _04933_ _04927_ VSS VSS VDD VDD _01140_ _04930_ sky130_fd_sc_hd__ha_1
X_10145_ net441 _05502_ VSS VSS VDD VDD _04931_ _04940_ sky130_fd_sc_hd__ha_1
X_10146_ net441 net440 VSS VSS VDD VDD _05397_ _05504_ sky130_fd_sc_hd__ha_1
X_10147_ _01142_ _04934_ VSS VSS VDD VDD _05505_ _04938_ sky130_fd_sc_hd__ha_1
X_10148_ _04916_ _05505_ VSS VSS VDD VDD _01143_ _04936_ sky130_fd_sc_hd__ha_1
X_10149_ _01144_ _01145_ VSS VSS VDD VDD _01146_ _01147_ sky130_fd_sc_hd__ha_1
X_10150_ net442 net441 VSS VSS VDD VDD _05382_ _05506_ sky130_fd_sc_hd__ha_1
X_10151_ _01149_ _01150_ VSS VSS VDD VDD _05507_ _04946_ sky130_fd_sc_hd__ha_1
X_10152_ _00078_ _04947_ VSS VSS VDD VDD _05508_ _05509_ sky130_fd_sc_hd__ha_1
X_10153_ _01151_ _05507_ VSS VSS VDD VDD _01152_ _04943_ sky130_fd_sc_hd__ha_1
X_10154_ _01153_ net443 VSS VSS VDD VDD _05055_ _00001_ sky130_fd_sc_hd__ha_1
X_10155_ stage3_in_r\[17\] net443 VSS VSS VDD VDD _04947_
+ _05510_ sky130_fd_sc_hd__ha_1
X_10156_ net443 net442 VSS VSS VDD VDD _05276_ _05511_ sky130_fd_sc_hd__ha_1
X_10157_ _04954_ _01154_ VSS VSS VDD VDD _05512_ _01155_ sky130_fd_sc_hd__ha_1
X_10158_ _01156_ _00002_ VSS VSS VDD VDD _05513_ _05514_ sky130_fd_sc_hd__ha_1
X_10159_ _05512_ _00023_ VSS VSS VDD VDD _04949_ _04953_ sky130_fd_sc_hd__ha_1
X_10160_ _04951_ _01157_ VSS VSS VDD VDD _01158_ _01159_ sky130_fd_sc_hd__ha_1
X_10161_ net444 net443 VSS VSS VDD VDD _01160_ _05515_ sky130_fd_sc_hd__ha_1
X_10162_ _04959_ _04955_ VSS VSS VDD VDD _05516_ _05517_ sky130_fd_sc_hd__ha_1
X_10163_ _05516_ _00039_ VSS VSS VDD VDD _01161_ _04956_ sky130_fd_sc_hd__ha_1
X_10164_ _01162_ _04952_ VSS VSS VDD VDD _01163_ _01164_ sky130_fd_sc_hd__ha_1
X_10165_ _05517_ _01131_ VSS VSS VDD VDD _04957_ _04963_ sky130_fd_sc_hd__ha_1
X_10166_ stage3_in_r\[17\] net444 VSS VSS VDD VDD _05284_
+ _05518_ sky130_fd_sc_hd__ha_1
X_10167_ _01165_ _04960_ VSS VSS VDD VDD _05519_ _05520_ sky130_fd_sc_hd__ha_1
X_10168_ _05519_ _00055_ VSS VSS VDD VDD _01166_ _04961_ sky130_fd_sc_hd__ha_1
X_10169_ _01167_ _01168_ VSS VSS VDD VDD _01169_ _01170_ sky130_fd_sc_hd__ha_1
X_10170_ _01171_ _01172_ VSS VSS VDD VDD _01173_ _01174_ sky130_fd_sc_hd__ha_1
X_10171_ stage3_in_r\[17\] _05520_ VSS VSS VDD VDD _04962_
+ _01175_ sky130_fd_sc_hd__ha_1
X_10172_ net445 stage3_in_r\[17\] VSS VSS VDD VDD _00123_
+ _05521_ sky130_fd_sc_hd__ha_1
X_10173_ _04971_ _01176_ VSS VSS VDD VDD _05522_ _05523_ sky130_fd_sc_hd__ha_1
X_10174_ _05522_ _01141_ VSS VSS VDD VDD _04966_ _01177_ sky130_fd_sc_hd__ha_1
X_10175_ _04967_ _01179_ VSS VSS VDD VDD _01180_ _01181_ sky130_fd_sc_hd__ha_1
X_10176_ _04970_ _00123_ VSS VSS VDD VDD _05524_ _05525_ sky130_fd_sc_hd__ha_1
X_10177_ _05526_ _01148_ VSS VSS VDD VDD _04973_ _05527_ sky130_fd_sc_hd__ha_1
X_10178_ net445 _05523_ VSS VSS VDD VDD _01178_ _05528_ sky130_fd_sc_hd__ha_1
X_10179_ _04975_ _04968_ VSS VSS VDD VDD _01182_ _01183_ sky130_fd_sc_hd__ha_1
X_10180_ _05528_ _05527_ VSS VSS VDD VDD _04974_ _01184_ sky130_fd_sc_hd__ha_1
X_10181_ _05529_ _00089_ VSS VSS VDD VDD _01185_ _05530_ sky130_fd_sc_hd__ha_1
X_10182_ _04972_ _04977_ VSS VSS VDD VDD _05526_ _05531_ sky130_fd_sc_hd__ha_1
X_10183_ _01187_ _04976_ VSS VSS VDD VDD _01188_ _01189_ sky130_fd_sc_hd__ha_1
X_10184_ _05531_ _05530_ VSS VSS VDD VDD _01186_ _01190_ sky130_fd_sc_hd__ha_1
X_10185_ _05521_ _00104_ VSS VSS VDD VDD _05532_ _05533_ sky130_fd_sc_hd__ha_1
X_10186_ _05534_ _04958_ VSS VSS VDD VDD _01191_ _05535_ sky130_fd_sc_hd__ha_1
X_10187_ _04978_ _05532_ VSS VSS VDD VDD _05529_ _05536_ sky130_fd_sc_hd__ha_1
X_10188_ _01193_ _01194_ VSS VSS VDD VDD _01195_ _01196_ sky130_fd_sc_hd__ha_1
X_10189_ _05536_ _05535_ VSS VSS VDD VDD _01192_ _05537_ sky130_fd_sc_hd__ha_1
X_10190_ _05533_ _05538_ VSS VSS VDD VDD _05534_ _05539_ sky130_fd_sc_hd__ha_1
X_10191_ _05540_ _01197_ VSS VSS VDD VDD _01198_ _01199_ sky130_fd_sc_hd__ha_1
X_10192_ _05541_ _05537_ VSS VSS VDD VDD _05540_ _01200_ sky130_fd_sc_hd__ha_1
X_10193_ _05539_ _00115_ VSS VSS VDD VDD _05541_ _05542_ sky130_fd_sc_hd__ha_1
X_10194_ net445 _04965_ VSS VSS VDD VDD _05538_ _05543_ sky130_fd_sc_hd__ha_1
X_10195_ _01201_ _01200_ VSS VSS VDD VDD _01202_ _01203_ sky130_fd_sc_hd__ha_1
X_10196_ _05544_ _05542_ VSS VSS VDD VDD _01201_ _05545_ sky130_fd_sc_hd__ha_1
X_10197_ _05543_ _04969_ VSS VSS VDD VDD _05544_ _05546_ sky130_fd_sc_hd__ha_1
X_10198_ stage3_in_r\[8\] _05547_ VSS VSS VDD VDD _05066_
+ _01204_ sky130_fd_sc_hd__ha_1
X_10199_ stage3_in_r\[0\] stage3_in_r\[2\] VSS VSS VDD VDD
+ _00219_ _04991_ sky130_fd_sc_hd__ha_1
X_10200_ _00204_ stage3_in_r\[7\] VSS VSS VDD VDD _05128_
+ _00362_ sky130_fd_sc_hd__ha_1
X_10201_ stage3_in_r\[5\] stage3_in_r\[7\] VSS VSS VDD VDD
+ _05547_ _05548_ sky130_fd_sc_hd__ha_1
X_10202_ stage3_in_r\[13\] stage3_in_r\[14\] VSS VSS VDD VDD
+ _05549_ _01205_ sky130_fd_sc_hd__ha_1
X_10203_ stage3_in_r\[9\] stage3_in_r\[10\] VSS VSS VDD VDD
+ _04985_ _00161_ sky130_fd_sc_hd__ha_1
X_10204_ _01206_ _04987_ VSS VSS VDD VDD _05550_ _01207_ sky130_fd_sc_hd__ha_1
X_10205_ stage3_in_r\[1\] stage3_in_r\[4\] VSS VSS VDD VDD
+ _04990_ _01208_ sky130_fd_sc_hd__ha_1
X_10206_ _04997_ _01210_ VSS VSS VDD VDD _05551_ _04995_ sky130_fd_sc_hd__ha_1
X_10207_ _00180_ _05551_ VSS VSS VDD VDD _00304_ _01211_ sky130_fd_sc_hd__ha_1
X_10208_ stage3_in_r\[0\] stage3_in_r\[3\] VSS VSS VDD VDD
+ _01209_ _05552_ sky130_fd_sc_hd__ha_1
X_10209_ _05005_ _04998_ VSS VSS VDD VDD _04999_ _05002_ sky130_fd_sc_hd__ha_1
X_10210_ stage3_in_r\[5\] _05552_ VSS VSS VDD VDD _05003_
+ _05012_ sky130_fd_sc_hd__ha_1
X_10211_ _01213_ _05006_ VSS VSS VDD VDD _05553_ _05010_ sky130_fd_sc_hd__ha_1
X_10212_ _00140_ _05553_ VSS VSS VDD VDD _01214_ _05008_ sky130_fd_sc_hd__ha_1
X_10213_ _01215_ _01216_ VSS VSS VDD VDD _01217_ _01218_ sky130_fd_sc_hd__ha_1
X_10214_ _01220_ _01221_ VSS VSS VDD VDD _05554_ _05018_ sky130_fd_sc_hd__ha_1
X_10215_ _01222_ _05554_ VSS VSS VDD VDD _01223_ _05015_ sky130_fd_sc_hd__ha_1
X_10216_ _01224_ stage3_in_r\[3\] VSS VSS VDD VDD _05063_
+ _00135_ sky130_fd_sc_hd__ha_1
X_10217_ stage3_in_r\[1\] stage3_in_r\[3\] VSS VSS VDD VDD
+ _05019_ _05555_ sky130_fd_sc_hd__ha_1
X_10218_ _05029_ _01225_ VSS VSS VDD VDD _05556_ _05027_ sky130_fd_sc_hd__ha_1
X_10219_ _05556_ _00160_ VSS VSS VDD VDD _05021_ _05025_ sky130_fd_sc_hd__ha_1
X_10220_ _05023_ _01226_ VSS VSS VDD VDD _01227_ _01228_ sky130_fd_sc_hd__ha_1
X_10221_ _05034_ _05030_ VSS VSS VDD VDD _05557_ _05558_ sky130_fd_sc_hd__ha_1
X_10222_ _05557_ _00175_ VSS VSS VDD VDD _01229_ _05031_ sky130_fd_sc_hd__ha_1
X_10223_ _01230_ _05024_ VSS VSS VDD VDD _01231_ _01232_ sky130_fd_sc_hd__ha_1
X_10224_ _05558_ _04991_ VSS VSS VDD VDD _05032_ _05038_ sky130_fd_sc_hd__ha_1
X_10225_ _01233_ _05035_ VSS VSS VDD VDD _05559_ _05560_ sky130_fd_sc_hd__ha_1
X_10226_ _05559_ _00189_ VSS VSS VDD VDD _01234_ _05036_ sky130_fd_sc_hd__ha_1
X_10227_ _01235_ _01236_ VSS VSS VDD VDD _01237_ _01238_ sky130_fd_sc_hd__ha_1
X_10228_ _01239_ _01240_ VSS VSS VDD VDD _01241_ _01242_ sky130_fd_sc_hd__ha_1
X_10229_ stage3_in_r\[1\] _05560_ VSS VSS VDD VDD _05037_
+ _01243_ sky130_fd_sc_hd__ha_1
X_10230_ stage3_in_r\[0\] stage3_in_r\[1\] VSS VSS VDD VDD
+ _05052_ _01244_ sky130_fd_sc_hd__ha_1
X_10231_ _05046_ _01245_ VSS VSS VDD VDD _05561_ _05562_ sky130_fd_sc_hd__ha_1
X_10232_ _05561_ _01212_ VSS VSS VDD VDD _05041_ _01246_ sky130_fd_sc_hd__ha_1
X_10233_ _05042_ _01248_ VSS VSS VDD VDD _01249_ _01250_ sky130_fd_sc_hd__ha_1
X_10234_ _05045_ _05052_ VSS VSS VDD VDD _05563_ _01251_ sky130_fd_sc_hd__ha_1
X_10235_ _05564_ _01219_ VSS VSS VDD VDD _05048_ _05565_ sky130_fd_sc_hd__ha_1
X_10236_ stage3_in_r\[0\] _05562_ VSS VSS VDD VDD _01247_
+ _05566_ sky130_fd_sc_hd__ha_1
X_10237_ _05050_ _05043_ VSS VSS VDD VDD _01252_ _01253_ sky130_fd_sc_hd__ha_1
X_10238_ _05566_ _05565_ VSS VSS VDD VDD _05049_ _01254_ sky130_fd_sc_hd__ha_1
X_10239_ _05567_ _00220_ VSS VSS VDD VDD _01255_ _05568_ sky130_fd_sc_hd__ha_1
X_10240_ _05047_ _05053_ VSS VSS VDD VDD _05564_ _05569_ sky130_fd_sc_hd__ha_1
X_10241_ _01257_ _05051_ VSS VSS VDD VDD _01258_ _01259_ sky130_fd_sc_hd__ha_1
X_10242_ _05569_ _05568_ VSS VSS VDD VDD _01256_ _01260_ sky130_fd_sc_hd__ha_1
X_10243_ _01244_ _00234_ VSS VSS VDD VDD _05570_ _05571_ sky130_fd_sc_hd__ha_1
X_10244_ _05572_ _05033_ VSS VSS VDD VDD _01261_ _05573_ sky130_fd_sc_hd__ha_1
X_10245_ _05054_ _05570_ VSS VSS VDD VDD _05567_ _05574_ sky130_fd_sc_hd__ha_1
X_10246_ _01263_ _01264_ VSS VSS VDD VDD _01265_ _01266_ sky130_fd_sc_hd__ha_1
X_10247_ _05574_ _05573_ VSS VSS VDD VDD _01262_ _05575_ sky130_fd_sc_hd__ha_1
X_10248_ _05571_ _05576_ VSS VSS VDD VDD _05572_ _05577_ sky130_fd_sc_hd__ha_1
X_10249_ _05578_ _01267_ VSS VSS VDD VDD _01268_ _01269_ sky130_fd_sc_hd__ha_1
X_10250_ _05579_ _05575_ VSS VSS VDD VDD _05578_ _01270_ sky130_fd_sc_hd__ha_1
X_10251_ _05577_ _00245_ VSS VSS VDD VDD _05579_ _05580_ sky130_fd_sc_hd__ha_1
X_10252_ stage3_in_r\[0\] _05040_ VSS VSS VDD VDD _05576_
+ _05581_ sky130_fd_sc_hd__ha_1
X_10253_ _01271_ _01270_ VSS VSS VDD VDD _01272_ _01273_ sky130_fd_sc_hd__ha_1
X_10254_ _05582_ _05580_ VSS VSS VDD VDD _01271_ _05583_ sky130_fd_sc_hd__ha_1
X_10255_ _05581_ _05044_ VSS VSS VDD VDD _05582_ _05584_ sky130_fd_sc_hd__ha_1
X_10256_ _01274_ _01275_ VSS VSS VDD VDD _01276_ _01277_ sky130_fd_sc_hd__ha_1
X_10257_ _01278_ _01275_ VSS VSS VDD VDD _01279_ _05585_ sky130_fd_sc_hd__ha_1
X_10258_ _05586_ _05545_ VSS VSS VDD VDD _01280_ _05587_ sky130_fd_sc_hd__ha_1
X_10259_ _05588_ _05583_ VSS VSS VDD VDD _01281_ _01282_ sky130_fd_sc_hd__ha_1
X_10260_ _05546_ _05524_ VSS VSS VDD VDD _05586_ _05589_ sky130_fd_sc_hd__ha_1
X_10261_ _05584_ _05563_ VSS VSS VDD VDD _05588_ _01283_ sky130_fd_sc_hd__ha_1
X_10262_ _01284_ net442 VSS VSS VDD VDD _05072_ _00273_ sky130_fd_sc_hd__ha_1
X_10263_ net444 net442 VSS VSS VDD VDD _04939_ _05590_ sky130_fd_sc_hd__ha_1
X_10264_ _01285_ _05499_ VSS VSS VDD VDD _00319_ _01286_ sky130_fd_sc_hd__ha_1
X_10265_ _01287_ _01288_ VSS VSS VDD VDD _01289_ _01290_ sky130_fd_sc_hd__ha_1
X_10266_ _01291_ stage3_in_r\[4\] VSS VSS VDD VDD _05082_
+ _00289_ sky130_fd_sc_hd__ha_1
X_10267_ stage3_in_r\[2\] stage3_in_r\[4\] VSS VSS VDD VDD
+ _05011_ _05591_ sky130_fd_sc_hd__ha_1
X_10268_ _01292_ _05550_ VSS VSS VDD VDD _00331_ _01293_ sky130_fd_sc_hd__ha_1
X_10269_ _01294_ _01295_ VSS VSS VDD VDD _01296_ _01297_ sky130_fd_sc_hd__ha_1
X_10270_ net434 net433 VSS VSS VDD VDD _01298_ _01299_ sky130_fd_sc_hd__ha_1
X_10271_ _00276_ _01300_ VSS VSS VDD VDD _01301_ _01302_ sky130_fd_sc_hd__ha_1
X_10272_ net432 _01303_ VSS VSS VDD VDD _00341_ _01304_ sky130_fd_sc_hd__ha_1
X_10273_ _01305_ _01306_ VSS VSS VDD VDD _01307_ _01308_ sky130_fd_sc_hd__ha_1
X_10274_ _00222_ stage3_in_r\[5\] VSS VSS VDD VDD _05099_
+ _05081_ sky130_fd_sc_hd__ha_1
X_10275_ _05085_ _00180_ VSS VSS VDD VDD _05592_ _01309_ sky130_fd_sc_hd__ha_1
X_10276_ _01310_ _05086_ VSS VSS VDD VDD _01311_ _01312_ sky130_fd_sc_hd__ha_1
X_10277_ _01313_ _05067_ VSS VSS VDD VDD _00351_ _01314_ sky130_fd_sc_hd__ha_1
X_10278_ _01315_ _01316_ VSS VSS VDD VDD _01317_ _01318_ sky130_fd_sc_hd__ha_1
X_10279_ _01319_ _05075_ VSS VSS VDD VDD _01320_ _01321_ sky130_fd_sc_hd__ha_1
X_10280_ _01322_ _01323_ VSS VSS VDD VDD _01324_ _01325_ sky130_fd_sc_hd__ha_1
X_10281_ _00215_ stage3_in_r\[6\] VSS VSS VDD VDD _05113_
+ _05100_ sky130_fd_sc_hd__ha_1
X_10282_ _00323_ _01326_ VSS VSS VDD VDD _01327_ _01328_ sky130_fd_sc_hd__ha_1
X_10283_ _01329_ _01330_ VSS VSS VDD VDD _01331_ _01332_ sky130_fd_sc_hd__ha_1
X_10284_ _00071_ net439 VSS VSS VDD VDD _05121_ _00014_ sky130_fd_sc_hd__ha_1
X_10285_ net441 net439 VSS VSS VDD VDD _01129_ _05593_ sky130_fd_sc_hd__ha_1
X_10286_ net431 _01285_ VSS VSS VDD VDD _01333_ _01334_ sky130_fd_sc_hd__ha_1
X_10287_ net431 _01335_ VSS VSS VDD VDD _01336_ _05594_ sky130_fd_sc_hd__ha_1
X_10288_ _01337_ _01338_ VSS VSS VDD VDD _01339_ _01340_ sky130_fd_sc_hd__ha_1
X_10289_ _01341_ _01342_ VSS VSS VDD VDD _01343_ _01344_ sky130_fd_sc_hd__ha_1
X_10290_ _01345_ _04983_ VSS VSS VDD VDD _01346_ _01347_ sky130_fd_sc_hd__ha_1
X_10291_ _01348_ _01349_ VSS VSS VDD VDD _01350_ _01351_ sky130_fd_sc_hd__ha_1
X_10292_ stage3_in_r\[149\] _01352_ VSS VSS VDD VDD _01353_
+ _01354_ sky130_fd_sc_hd__ha_1
X_10293_ stage3_in_r\[149\] _01355_ VSS VSS VDD VDD _01356_
+ _05595_ sky130_fd_sc_hd__ha_1
X_10294_ net431 _01357_ VSS VSS VDD VDD _00424_ _01358_ sky130_fd_sc_hd__ha_1
X_10295_ net431 _01359_ VSS VSS VDD VDD _01360_ _05596_ sky130_fd_sc_hd__ha_1
X_10296_ _01361_ _01362_ VSS VSS VDD VDD _01363_ _01364_ sky130_fd_sc_hd__ha_1
X_10297_ _00170_ stage3_in_r\[8\] VSS VSS VDD VDD _05137_
+ _05127_ sky130_fd_sc_hd__ha_1
X_10298_ net459 _01313_ VSS VSS VDD VDD _01365_ _01366_ sky130_fd_sc_hd__ha_1
X_10299_ net459 _01367_ VSS VSS VDD VDD _01368_ _05597_ sky130_fd_sc_hd__ha_1
X_10300_ _01292_ _01369_ VSS VSS VDD VDD _01370_ _01371_ sky130_fd_sc_hd__ha_1
X_10301_ _01372_ _01373_ VSS VSS VDD VDD _01374_ _01375_ sky130_fd_sc_hd__ha_1
X_10302_ stage3_in_r\[150\] _01376_ VSS VSS VDD VDD _01377_
+ _01378_ sky130_fd_sc_hd__ha_1
X_10303_ stage3_in_r\[150\] _01379_ VSS VSS VDD VDD _01380_
+ _05598_ sky130_fd_sc_hd__ha_1
X_10304_ _01383_ _01384_ VSS VSS VDD VDD _05599_ _01385_ sky130_fd_sc_hd__ha_1
X_10305_ _01386_ _01387_ VSS VSS VDD VDD _01388_ _01389_ sky130_fd_sc_hd__ha_1
X_10306_ _00178_ stage3_in_r\[9\] VSS VSS VDD VDD _01390_
+ _05138_ sky130_fd_sc_hd__ha_1
X_10307_ net459 _01391_ VSS VSS VDD VDD _00453_ _01392_ sky130_fd_sc_hd__ha_1
X_10308_ net459 _01393_ VSS VSS VDD VDD _01394_ _05600_ sky130_fd_sc_hd__ha_1
X_10309_ _01395_ _01396_ VSS VSS VDD VDD _01397_ _01398_ sky130_fd_sc_hd__ha_1
X_10310_ stage3_in_r\[151\] _01399_ VSS VSS VDD VDD _01400_
+ _01401_ sky130_fd_sc_hd__ha_1
X_10311_ stage3_in_r\[151\] _01402_ VSS VSS VDD VDD _01403_
+ _05601_ sky130_fd_sc_hd__ha_1
X_10312_ _01406_ _05146_ VSS VSS VDD VDD _05602_ _05603_ sky130_fd_sc_hd__ha_1
X_10313_ _05599_ _05603_ VSS VSS VDD VDD _01407_ _00425_ sky130_fd_sc_hd__ha_1
X_10314_ _01408_ _01409_ VSS VSS VDD VDD _01410_ _01411_ sky130_fd_sc_hd__ha_1
X_10315_ _00162_ stage3_in_r\[10\] VSS VSS VDD VDD _01412_
+ _01413_ sky130_fd_sc_hd__ha_1
X_10316_ _01414_ _05148_ VSS VSS VDD VDD _05604_ _01415_ sky130_fd_sc_hd__ha_1
X_10317_ _01416_ _01417_ VSS VSS VDD VDD _01418_ _01419_ sky130_fd_sc_hd__ha_1
X_10318_ stage3_in_r\[152\] _01420_ VSS VSS VDD VDD _01421_
+ _01422_ sky130_fd_sc_hd__ha_1
X_10319_ stage3_in_r\[152\] _01423_ VSS VSS VDD VDD _01424_
+ _05605_ sky130_fd_sc_hd__ha_1
X_10320_ _05151_ _00436_ VSS VSS VDD VDD _05606_ _01425_ sky130_fd_sc_hd__ha_1
X_10321_ _05145_ _01426_ VSS VSS VDD VDD _05607_ _05608_ sky130_fd_sc_hd__ha_1
X_10322_ _05602_ _05608_ VSS VSS VDD VDD _01427_ _01428_ sky130_fd_sc_hd__ha_1
X_10323_ _01429_ _01430_ VSS VSS VDD VDD _01431_ _01432_ sky130_fd_sc_hd__ha_1
X_10324_ _00163_ stage3_in_r\[11\] VSS VSS VDD VDD _05155_
+ _01433_ sky130_fd_sc_hd__ha_1
X_10325_ _05147_ _05153_ VSS VSS VDD VDD _05609_ _05610_ sky130_fd_sc_hd__ha_1
X_10326_ _05604_ _05610_ VSS VSS VDD VDD _01434_ _00454_ sky130_fd_sc_hd__ha_1
X_10327_ _01435_ _01436_ VSS VSS VDD VDD _01437_ _01438_ sky130_fd_sc_hd__ha_1
X_10328_ _05154_ _00455_ VSS VSS VDD VDD _05611_ _01439_ sky130_fd_sc_hd__ha_1
X_10329_ _01440_ _01441_ VSS VSS VDD VDD _05612_ _05613_ sky130_fd_sc_hd__ha_1
X_10330_ _05607_ _05613_ VSS VSS VDD VDD _01442_ _01443_ sky130_fd_sc_hd__ha_1
X_10331_ _01444_ _01445_ VSS VSS VDD VDD _01446_ _01447_ sky130_fd_sc_hd__ha_1
X_10332_ _00164_ stage3_in_r\[12\] VSS VSS VDD VDD _05158_
+ _05156_ sky130_fd_sc_hd__ha_1
X_10333_ _05155_ _05156_ VSS VSS VDD VDD _05614_ _01448_ sky130_fd_sc_hd__ha_1
X_10334_ _05152_ _01449_ VSS VSS VDD VDD _05615_ _05616_ sky130_fd_sc_hd__ha_1
X_10335_ _05609_ _05616_ VSS VSS VDD VDD _01450_ _01451_ sky130_fd_sc_hd__ha_1
X_10336_ _01452_ _01453_ VSS VSS VDD VDD _01454_ _01455_ sky130_fd_sc_hd__ha_1
X_10337_ _05157_ _00468_ VSS VSS VDD VDD _05617_ _01456_ sky130_fd_sc_hd__ha_1
X_10338_ _01457_ _01458_ VSS VSS VDD VDD _05618_ _05619_ sky130_fd_sc_hd__ha_1
X_10339_ _05612_ _05619_ VSS VSS VDD VDD _01459_ _01460_ sky130_fd_sc_hd__ha_1
X_10340_ _01461_ _01462_ VSS VSS VDD VDD _01463_ _01464_ sky130_fd_sc_hd__ha_1
X_10341_ _00147_ stage3_in_r\[13\] VSS VSS VDD VDD _05160_
+ _05159_ sky130_fd_sc_hd__ha_1
X_10342_ _05158_ _05159_ VSS VSS VDD VDD _05620_ _01465_ sky130_fd_sc_hd__ha_1
X_10343_ _01466_ _01467_ VSS VSS VDD VDD _05621_ _05622_ sky130_fd_sc_hd__ha_1
X_10344_ _05615_ _05622_ VSS VSS VDD VDD _01468_ _01469_ sky130_fd_sc_hd__ha_1
X_10345_ _01470_ _01471_ VSS VSS VDD VDD _01472_ _01473_ sky130_fd_sc_hd__ha_1
X_10346_ _01474_ _01475_ VSS VSS VDD VDD _05623_ _05624_ sky130_fd_sc_hd__ha_1
X_10347_ _05618_ _05624_ VSS VSS VDD VDD _01476_ _01477_ sky130_fd_sc_hd__ha_1
X_10348_ _01478_ _01479_ VSS VSS VDD VDD _01480_ _01481_ sky130_fd_sc_hd__ha_1
X_10349_ _00148_ stage3_in_r\[14\] VSS VSS VDD VDD _01482_
+ _05161_ sky130_fd_sc_hd__ha_1
X_10350_ _05160_ _05161_ VSS VSS VDD VDD _05625_ _01483_ sky130_fd_sc_hd__ha_1
X_10351_ _01484_ _01485_ VSS VSS VDD VDD _05626_ _05627_ sky130_fd_sc_hd__ha_1
X_10352_ _05621_ _05627_ VSS VSS VDD VDD _01486_ _01487_ sky130_fd_sc_hd__ha_1
X_10353_ _01488_ _01489_ VSS VSS VDD VDD _01490_ _01491_ sky130_fd_sc_hd__ha_1
X_10354_ _00309_ stage3_in_r\[30\] VSS VSS VDD VDD _01027_
+ _00934_ sky130_fd_sc_hd__ha_1
X_10355_ net428 net431 VSS VSS VDD VDD _01492_ _05628_ sky130_fd_sc_hd__ha_1
X_10356_ net433 net431 VSS VSS VDD VDD _01493_ _05629_ sky130_fd_sc_hd__ha_1
X_10357_ net433 net431 VSS VSS VDD VDD _01494_ _05630_ sky130_fd_sc_hd__ha_1
X_10358_ _01495_ _01496_ VSS VSS VDD VDD _05631_ _05632_ sky130_fd_sc_hd__ha_1
X_10359_ _05623_ _05632_ VSS VSS VDD VDD _01497_ _01498_ sky130_fd_sc_hd__ha_1
X_10360_ _01499_ _01500_ VSS VSS VDD VDD _01501_ _01502_ sky130_fd_sc_hd__ha_1
X_10361_ _00141_ net459 VSS VSS VDD VDD _01503_ _01504_ sky130_fd_sc_hd__ha_1
X_10362_ _01505_ _01506_ VSS VSS VDD VDD _05633_ _05634_ sky130_fd_sc_hd__ha_1
X_10363_ _05626_ _05634_ VSS VSS VDD VDD _01507_ _01508_ sky130_fd_sc_hd__ha_1
X_10364_ _01509_ _01510_ VSS VSS VDD VDD _01511_ _01512_ sky130_fd_sc_hd__ha_1
X_10365_ _01513_ _01514_ VSS VSS VDD VDD _01515_ _05635_ sky130_fd_sc_hd__ha_1
X_10366_ _05631_ _05635_ VSS VSS VDD VDD _01516_ _01517_ sky130_fd_sc_hd__ha_1
X_10367_ _01518_ _01519_ VSS VSS VDD VDD _01520_ _01521_ sky130_fd_sc_hd__ha_1
X_10368_ _00142_ net459 VSS VSS VDD VDD _01522_ _01523_ sky130_fd_sc_hd__ha_1
X_10369_ stage3_in_r\[14\] net459 VSS VSS VDD VDD _01524_
+ _05636_ sky130_fd_sc_hd__ha_1
X_10370_ stage3_in_r\[14\] net459 VSS VSS VDD VDD _01525_
+ _05637_ sky130_fd_sc_hd__ha_1
X_10371_ _01526_ _01527_ VSS VSS VDD VDD _01528_ _05638_ sky130_fd_sc_hd__ha_1
X_10372_ _05633_ _05638_ VSS VSS VDD VDD _01529_ _01530_ sky130_fd_sc_hd__ha_1
X_10373_ _01531_ _01532_ VSS VSS VDD VDD _01533_ _01534_ sky130_fd_sc_hd__ha_1
X_10374_ _01535_ _01536_ VSS VSS VDD VDD _01537_ _01538_ sky130_fd_sc_hd__ha_1
X_10375_ _01539_ _01536_ VSS VSS VDD VDD _01540_ _05639_ sky130_fd_sc_hd__ha_1
X_10376_ stage3_in_r\[145\] _01118_ VSS VSS VDD VDD _01541_
+ _01542_ sky130_fd_sc_hd__ha_1
X_10377_ stage3_in_r\[145\] _01121_ VSS VSS VDD VDD _01543_
+ _05640_ sky130_fd_sc_hd__ha_1
X_10378_ stage3_in_r\[146\] _01544_ VSS VSS VDD VDD _01545_
+ _01546_ sky130_fd_sc_hd__ha_1
X_10379_ stage3_in_r\[146\] _01547_ VSS VSS VDD VDD _01548_
+ _05641_ sky130_fd_sc_hd__ha_1
X_10380_ stage3_in_r\[147\] _01549_ VSS VSS VDD VDD _01550_
+ _01551_ sky130_fd_sc_hd__ha_1
X_10381_ stage3_in_r\[147\] _01552_ VSS VSS VDD VDD _01553_
+ _05642_ sky130_fd_sc_hd__ha_1
X_10382_ stage3_in_r\[148\] _01554_ VSS VSS VDD VDD _01555_
+ _01556_ sky130_fd_sc_hd__ha_1
X_10383_ stage3_in_r\[148\] _01557_ VSS VSS VDD VDD _01558_
+ _05643_ sky130_fd_sc_hd__ha_1
X_10384_ stage3_in_r\[153\] _01559_ VSS VSS VDD VDD _01560_
+ _01561_ sky130_fd_sc_hd__ha_1
X_10385_ stage3_in_r\[153\] _01562_ VSS VSS VDD VDD _01563_
+ _05644_ sky130_fd_sc_hd__ha_1
X_10386_ stage3_in_r\[154\] _01564_ VSS VSS VDD VDD _01565_
+ _01566_ sky130_fd_sc_hd__ha_1
X_10387_ stage3_in_r\[154\] _01567_ VSS VSS VDD VDD _01568_
+ _05645_ sky130_fd_sc_hd__ha_1
X_10388_ stage3_in_r\[155\] _01569_ VSS VSS VDD VDD _01570_
+ _01571_ sky130_fd_sc_hd__ha_1
X_10389_ stage3_in_r\[155\] _01572_ VSS VSS VDD VDD _01573_
+ _05646_ sky130_fd_sc_hd__ha_1
X_10390_ stage3_in_r\[156\] _01574_ VSS VSS VDD VDD _01575_
+ _01576_ sky130_fd_sc_hd__ha_1
X_10391_ stage3_in_r\[156\] _01577_ VSS VSS VDD VDD _01578_
+ _05647_ sky130_fd_sc_hd__ha_1
X_10392_ stage3_in_r\[157\] _01579_ VSS VSS VDD VDD _01580_
+ _01581_ sky130_fd_sc_hd__ha_1
X_10393_ stage3_in_r\[157\] _01582_ VSS VSS VDD VDD _01583_
+ _05648_ sky130_fd_sc_hd__ha_1
X_10394_ stage3_in_r\[158\] _01584_ VSS VSS VDD VDD _01585_
+ _01586_ sky130_fd_sc_hd__ha_1
X_10395_ stage3_in_r\[158\] _01587_ VSS VSS VDD VDD _01588_
+ _05649_ sky130_fd_sc_hd__ha_1
X_10396_ stage3_in_r\[158\] _01589_ VSS VSS VDD VDD _01590_
+ _01591_ sky130_fd_sc_hd__ha_1
X_10397_ stage3_in_r\[158\] _01592_ VSS VSS VDD VDD _01593_
+ _05650_ sky130_fd_sc_hd__ha_1
X_10398_ _01594_ _01595_ VSS VSS VDD VDD _01596_ _01597_ sky130_fd_sc_hd__ha_1
X_10399_ _01594_ _01598_ VSS VSS VDD VDD _01599_ _05651_ sky130_fd_sc_hd__ha_1
X_10400_ _01600_ _01601_ VSS VSS VDD VDD _01602_ _01603_ sky130_fd_sc_hd__ha_1
X_10401_ _01604_ _01601_ VSS VSS VDD VDD _01605_ _05652_ sky130_fd_sc_hd__ha_1
X_10402_ _01606_ _01607_ VSS VSS VDD VDD _01608_ _01609_ sky130_fd_sc_hd__ha_1
X_10403_ _01610_ _01607_ VSS VSS VDD VDD _01611_ _05653_ sky130_fd_sc_hd__ha_1
X_10404_ _01612_ _01613_ VSS VSS VDD VDD _01614_ _01615_ sky130_fd_sc_hd__ha_1
X_10405_ _01616_ _01613_ VSS VSS VDD VDD _01617_ _05654_ sky130_fd_sc_hd__ha_1
X_10406_ _01618_ _01619_ VSS VSS VDD VDD _01620_ _01621_ sky130_fd_sc_hd__ha_1
X_10407_ _01622_ _01619_ VSS VSS VDD VDD _01623_ _05655_ sky130_fd_sc_hd__ha_1
X_10408_ _01624_ _01625_ VSS VSS VDD VDD _01626_ _01627_ sky130_fd_sc_hd__ha_1
X_10409_ _01628_ _01625_ VSS VSS VDD VDD _01629_ _05656_ sky130_fd_sc_hd__ha_1
X_10410_ _01630_ _01631_ VSS VSS VDD VDD _01632_ _01633_ sky130_fd_sc_hd__ha_1
X_10411_ _01634_ _01631_ VSS VSS VDD VDD _01635_ _05657_ sky130_fd_sc_hd__ha_1
X_10412_ _01636_ _01637_ VSS VSS VDD VDD _01638_ _01639_ sky130_fd_sc_hd__ha_1
X_10413_ _01640_ _01637_ VSS VSS VDD VDD _01641_ _05658_ sky130_fd_sc_hd__ha_1
X_10414_ _01642_ _01643_ VSS VSS VDD VDD _01644_ _01645_ sky130_fd_sc_hd__ha_1
X_10415_ _01646_ _01643_ VSS VSS VDD VDD _01647_ _05659_ sky130_fd_sc_hd__ha_1
X_10416_ _01648_ _01649_ VSS VSS VDD VDD _01650_ _01651_ sky130_fd_sc_hd__ha_1
X_10417_ _00272_ _01649_ VSS VSS VDD VDD _01652_ _05660_ sky130_fd_sc_hd__ha_1
X_10418_ _01282_ _05587_ VSS VSS VDD VDD _01653_ _01654_ sky130_fd_sc_hd__ha_1
X_10419_ _01655_ _05587_ VSS VSS VDD VDD _01656_ _05661_ sky130_fd_sc_hd__ha_1
X_10420_ _01283_ _05589_ VSS VSS VDD VDD _01657_ _01658_ sky130_fd_sc_hd__ha_1
X_10421_ _01659_ _05589_ VSS VSS VDD VDD _01660_ _05662_ sky130_fd_sc_hd__ha_1
X_10422_ _01251_ _05525_ VSS VSS VDD VDD _01661_ _01662_ sky130_fd_sc_hd__ha_1
X_10423_ _01663_ _05525_ VSS VSS VDD VDD _01664_ _05663_ sky130_fd_sc_hd__ha_1
X_10424_ _01244_ _05521_ VSS VSS VDD VDD _01665_ _01666_ sky130_fd_sc_hd__ha_1
X_10425_ _01667_ _05521_ VSS VSS VDD VDD _01668_ _05664_ sky130_fd_sc_hd__ha_1
X_10426_ _01669_ _01670_ VSS VSS VDD VDD _01671_ _01672_ sky130_fd_sc_hd__ha_1
X_10427_ _01669_ _01673_ VSS VSS VDD VDD _01674_ _05665_ sky130_fd_sc_hd__ha_1
X_10428_ _01675_ _01676_ VSS VSS VDD VDD _01677_ _01678_ sky130_fd_sc_hd__ha_1
X_10429_ _01675_ _01679_ VSS VSS VDD VDD _01680_ _05666_ sky130_fd_sc_hd__ha_1
X_10430_ _01681_ _01682_ VSS VSS VDD VDD _01683_ _01684_ sky130_fd_sc_hd__ha_1
X_10431_ _01681_ _01685_ VSS VSS VDD VDD _01686_ _05667_ sky130_fd_sc_hd__ha_1
X_10432_ net422 _01688_ VSS VSS VDD VDD _01689_ _01690_ sky130_fd_sc_hd__ha_1
X_10433_ net422 _01691_ VSS VSS VDD VDD _01692_ _05668_ sky130_fd_sc_hd__ha_1
X_10434_ stage3_in_r\[133\] _01693_ VSS VSS VDD VDD _01694_
+ _01695_ sky130_fd_sc_hd__ha_1
X_10435_ stage3_in_r\[133\] _01696_ VSS VSS VDD VDD _01697_
+ _05669_ sky130_fd_sc_hd__ha_1
X_10436_ _01698_ _01699_ VSS VSS VDD VDD _01700_ _01701_ sky130_fd_sc_hd__ha_1
X_10437_ _01698_ _01702_ VSS VSS VDD VDD _01703_ _05670_ sky130_fd_sc_hd__ha_1
X_10438_ stage3_in_r\[134\] _01704_ VSS VSS VDD VDD _01705_
+ _01706_ sky130_fd_sc_hd__ha_1
X_10439_ stage3_in_r\[134\] _01707_ VSS VSS VDD VDD _01708_
+ _05671_ sky130_fd_sc_hd__ha_1
X_10440_ _01709_ _01710_ VSS VSS VDD VDD _01711_ _01712_ sky130_fd_sc_hd__ha_1
X_10441_ _01709_ _01713_ VSS VSS VDD VDD _01714_ _05672_ sky130_fd_sc_hd__ha_1
X_10442_ stage3_in_r\[135\] _01715_ VSS VSS VDD VDD _01716_
+ _01717_ sky130_fd_sc_hd__ha_1
X_10443_ stage3_in_r\[135\] _01718_ VSS VSS VDD VDD _01719_
+ _05673_ sky130_fd_sc_hd__ha_1
X_10444_ _01720_ _01721_ VSS VSS VDD VDD _01722_ _01723_ sky130_fd_sc_hd__ha_1
X_10445_ _01720_ net421 VSS VSS VDD VDD _01725_ _05674_ sky130_fd_sc_hd__ha_1
X_10446_ stage3_in_r\[136\] _01726_ VSS VSS VDD VDD _01727_
+ _01728_ sky130_fd_sc_hd__ha_1
X_10447_ stage3_in_r\[136\] _01729_ VSS VSS VDD VDD _01730_
+ _05675_ sky130_fd_sc_hd__ha_1
X_10448_ _01731_ _01732_ VSS VSS VDD VDD _01733_ _01734_ sky130_fd_sc_hd__ha_1
X_10449_ _01731_ _01735_ VSS VSS VDD VDD _01736_ _05676_ sky130_fd_sc_hd__ha_1
X_10450_ _01737_ _01738_ VSS VSS VDD VDD _01739_ _01740_ sky130_fd_sc_hd__ha_1
X_10451_ _01737_ _01741_ VSS VSS VDD VDD _01742_ _05677_ sky130_fd_sc_hd__ha_1
X_10452_ net417 _01744_ VSS VSS VDD VDD _01745_ _01746_ sky130_fd_sc_hd__ha_1
X_10453_ net417 _01747_ VSS VSS VDD VDD _01748_ _05678_ sky130_fd_sc_hd__ha_1
X_10454_ net416 _01750_ VSS VSS VDD VDD _01751_ _01752_ sky130_fd_sc_hd__ha_1
X_10455_ net416 _01753_ VSS VSS VDD VDD _01754_ _05679_ sky130_fd_sc_hd__ha_1
X_10456_ _01755_ _01756_ VSS VSS VDD VDD _01757_ _01758_ sky130_fd_sc_hd__ha_1
X_10457_ _01759_ _01756_ VSS VSS VDD VDD _01760_ _05680_ sky130_fd_sc_hd__ha_1
X_10458_ stage3_in_r\[129\] _01113_ VSS VSS VDD VDD _01761_
+ _01762_ sky130_fd_sc_hd__ha_1
X_10459_ stage3_in_r\[129\] _01116_ VSS VSS VDD VDD _01763_
+ _05681_ sky130_fd_sc_hd__ha_1
X_10460_ stage3_in_r\[130\] _01764_ VSS VSS VDD VDD _01765_
+ _01766_ sky130_fd_sc_hd__ha_1
X_10461_ stage3_in_r\[130\] _01767_ VSS VSS VDD VDD _01768_
+ _05682_ sky130_fd_sc_hd__ha_1
X_10462_ stage3_in_r\[131\] _01769_ VSS VSS VDD VDD _01770_
+ _01771_ sky130_fd_sc_hd__ha_1
X_10463_ stage3_in_r\[131\] _01772_ VSS VSS VDD VDD _01773_
+ _05683_ sky130_fd_sc_hd__ha_1
X_10464_ stage3_in_r\[132\] _01774_ VSS VSS VDD VDD _01775_
+ _01776_ sky130_fd_sc_hd__ha_1
X_10465_ stage3_in_r\[132\] _01777_ VSS VSS VDD VDD _01778_
+ _05684_ sky130_fd_sc_hd__ha_1
X_10466_ stage3_in_r\[137\] _01779_ VSS VSS VDD VDD _01780_
+ _01781_ sky130_fd_sc_hd__ha_1
X_10467_ stage3_in_r\[137\] _01782_ VSS VSS VDD VDD _01783_
+ _05685_ sky130_fd_sc_hd__ha_1
X_10468_ stage3_in_r\[138\] _01784_ VSS VSS VDD VDD _01785_
+ _01786_ sky130_fd_sc_hd__ha_1
X_10469_ stage3_in_r\[138\] _01787_ VSS VSS VDD VDD _01788_
+ _05686_ sky130_fd_sc_hd__ha_1
X_10470_ stage3_in_r\[139\] _01789_ VSS VSS VDD VDD _01790_
+ _01791_ sky130_fd_sc_hd__ha_1
X_10471_ stage3_in_r\[139\] _01792_ VSS VSS VDD VDD _01793_
+ _05687_ sky130_fd_sc_hd__ha_1
X_10472_ stage3_in_r\[140\] _01794_ VSS VSS VDD VDD _01795_
+ _01796_ sky130_fd_sc_hd__ha_1
X_10473_ stage3_in_r\[140\] _01797_ VSS VSS VDD VDD _01798_
+ _05688_ sky130_fd_sc_hd__ha_1
X_10474_ stage3_in_r\[141\] _01799_ VSS VSS VDD VDD _01800_
+ _01801_ sky130_fd_sc_hd__ha_1
X_10475_ stage3_in_r\[141\] _01802_ VSS VSS VDD VDD _01803_
+ _05689_ sky130_fd_sc_hd__ha_1
X_10476_ stage3_in_r\[142\] _01804_ VSS VSS VDD VDD _01805_
+ _01806_ sky130_fd_sc_hd__ha_1
X_10477_ stage3_in_r\[142\] _01807_ VSS VSS VDD VDD _01808_
+ _05690_ sky130_fd_sc_hd__ha_1
X_10478_ stage3_in_r\[143\] _01809_ VSS VSS VDD VDD _01810_
+ _01811_ sky130_fd_sc_hd__ha_1
X_10479_ stage3_in_r\[143\] _01812_ VSS VSS VDD VDD _01813_
+ _05691_ sky130_fd_sc_hd__ha_1
X_10480_ net453 net452 VSS VSS VDD VDD _05206_ _05692_ sky130_fd_sc_hd__ha_1
X_10481_ net455 _05692_ VSS VSS VDD VDD _01814_ _01815_ sky130_fd_sc_hd__ha_1
X_10482_ net454 net453 VSS VSS VDD VDD _05163_ _05693_ sky130_fd_sc_hd__ha_1
X_10483_ net456 _05693_ VSS VSS VDD VDD _01816_ _01817_ sky130_fd_sc_hd__ha_1
X_10484_ net455 net454 VSS VSS VDD VDD _01818_ _05694_ sky130_fd_sc_hd__ha_1
X_10485_ stage3_in_r\[78\] _01821_ VSS VSS VDD VDD _00548_
+ _01822_ sky130_fd_sc_hd__ha_1
X_10486_ net457 _05694_ VSS VSS VDD VDD _01820_ _05695_ sky130_fd_sc_hd__ha_1
X_10487_ stage3_in_r\[78\] _05173_ VSS VSS VDD VDD _05175_
+ _05179_ sky130_fd_sc_hd__ha_1
X_10488_ _05695_ _05174_ VSS VSS VDD VDD _05180_ _05191_ sky130_fd_sc_hd__ha_1
X_10489_ net456 net455 VSS VSS VDD VDD _05172_ _05696_ sky130_fd_sc_hd__ha_1
X_10490_ stage3_in_r\[77\] _05183_ VSS VSS VDD VDD _05185_
+ _05189_ sky130_fd_sc_hd__ha_1
X_10491_ _05187_ _05178_ VSS VSS VDD VDD _05697_ _05698_ sky130_fd_sc_hd__ha_1
X_10492_ _05696_ _05184_ VSS VSS VDD VDD _05190_ _05199_ sky130_fd_sc_hd__ha_1
X_10493_ _05340_ _01823_ VSS VSS VDD VDD _05699_ _05700_ sky130_fd_sc_hd__ha_1
X_10494_ stage3_in_r\[64\] stage3_in_r\[65\] VSS VSS VDD VDD
+ _00524_ _01824_ sky130_fd_sc_hd__ha_1
X_10495_ stage3_in_r\[76\] _05699_ VSS VSS VDD VDD _05193_
+ _05197_ sky130_fd_sc_hd__ha_1
X_10496_ _05701_ _05698_ VSS VSS VDD VDD _01825_ _01826_ sky130_fd_sc_hd__ha_1
X_10497_ _05195_ _05188_ VSS VSS VDD VDD _05701_ _05702_ sky130_fd_sc_hd__ha_1
X_10498_ _01824_ _05700_ VSS VSS VDD VDD _05198_ _01827_ sky130_fd_sc_hd__ha_1
X_10499_ _01828_ _01829_ VSS VSS VDD VDD _05703_ _05704_ sky130_fd_sc_hd__ha_1
X_10500_ net448 _05703_ VSS VSS VDD VDD _05201_ _01830_ sky130_fd_sc_hd__ha_1
X_10501_ _05705_ _05702_ VSS VSS VDD VDD _01832_ _01833_ sky130_fd_sc_hd__ha_1
X_10502_ _05202_ _05196_ VSS VSS VDD VDD _05705_ _05706_ sky130_fd_sc_hd__ha_1
X_10503_ net449 _05707_ VSS VSS VDD VDD _01834_ _05708_ sky130_fd_sc_hd__ha_1
X_10504_ net457 _05704_ VSS VSS VDD VDD _01831_ _05709_ sky130_fd_sc_hd__ha_1
X_10505_ _05710_ _05706_ VSS VSS VDD VDD _01836_ _01837_ sky130_fd_sc_hd__ha_1
X_10506_ _01838_ _05203_ VSS VSS VDD VDD _05710_ _05711_ sky130_fd_sc_hd__ha_1
X_10507_ _05709_ _05708_ VSS VSS VDD VDD _01835_ _05712_ sky130_fd_sc_hd__ha_1
X_10508_ _01839_ _01840_ VSS VSS VDD VDD _05707_ _05713_ sky130_fd_sc_hd__ha_1
X_10509_ _05714_ _05711_ VSS VSS VDD VDD _01841_ _01842_ sky130_fd_sc_hd__ha_1
X_10510_ _05715_ _01843_ VSS VSS VDD VDD _05714_ _05716_ sky130_fd_sc_hd__ha_1
X_10511_ _05717_ _05712_ VSS VSS VDD VDD _05715_ _05718_ sky130_fd_sc_hd__ha_1
X_10512_ net450 _05713_ VSS VSS VDD VDD _05717_ _05719_ sky130_fd_sc_hd__ha_1
X_10513_ stage3_in_r\[64\] net455 VSS VSS VDD VDD _01839_
+ _01844_ sky130_fd_sc_hd__ha_1
X_10514_ _05720_ _05716_ VSS VSS VDD VDD _01845_ _01846_ sky130_fd_sc_hd__ha_1
X_10515_ _05721_ _05718_ VSS VSS VDD VDD _05720_ _01847_ sky130_fd_sc_hd__ha_1
X_10516_ _05722_ _05719_ VSS VSS VDD VDD _05721_ _05723_ sky130_fd_sc_hd__ha_1
X_10517_ stage3_in_r\[72\] _01844_ VSS VSS VDD VDD _05722_
+ _05724_ sky130_fd_sc_hd__ha_1
X_10518_ _01848_ _01847_ VSS VSS VDD VDD _01849_ _01850_ sky130_fd_sc_hd__ha_1
X_10519_ _05725_ _05723_ VSS VSS VDD VDD _01848_ _05726_ sky130_fd_sc_hd__ha_1
X_10520_ _05727_ _05724_ VSS VSS VDD VDD _05725_ _05728_ sky130_fd_sc_hd__ha_1
X_10521_ net456 stage3_in_r\[71\] VSS VSS VDD VDD _05727_
+ _05729_ sky130_fd_sc_hd__ha_1
X_10522_ _01851_ _01852_ VSS VSS VDD VDD _01853_ _01854_ sky130_fd_sc_hd__ha_1
X_10523_ _01855_ _01607_ VSS VSS VDD VDD _01856_ _01857_ sky130_fd_sc_hd__ha_1
X_10524_ _01858_ _01613_ VSS VSS VDD VDD _01859_ _01860_ sky130_fd_sc_hd__ha_1
X_10525_ _01862_ _01619_ VSS VSS VDD VDD _01863_ _01864_ sky130_fd_sc_hd__ha_1
X_10526_ _05730_ _05726_ VSS VSS VDD VDD _01861_ _05731_ sky130_fd_sc_hd__ha_1
X_10527_ _05731_ _01625_ VSS VSS VDD VDD _01865_ _01866_ sky130_fd_sc_hd__ha_1
X_10528_ _05732_ _05728_ VSS VSS VDD VDD _05730_ _05733_ sky130_fd_sc_hd__ha_1
X_10529_ _05733_ _01631_ VSS VSS VDD VDD _01867_ _01868_ sky130_fd_sc_hd__ha_1
X_10530_ _05734_ _05729_ VSS VSS VDD VDD _05732_ _05735_ sky130_fd_sc_hd__ha_1
X_10531_ _05735_ _01637_ VSS VSS VDD VDD _01869_ _01870_ sky130_fd_sc_hd__ha_1
X_10532_ net457 net451 VSS VSS VDD VDD _05734_ _05736_ sky130_fd_sc_hd__ha_1
X_10533_ _05736_ _01643_ VSS VSS VDD VDD _01871_ _01872_ sky130_fd_sc_hd__ha_1
X_10534_ net452 _01649_ VSS VSS VDD VDD _01873_ _01874_ sky130_fd_sc_hd__ha_1
X_10535_ net453 _05587_ VSS VSS VDD VDD _01875_ _01876_ sky130_fd_sc_hd__ha_1
X_10536_ net454 _05589_ VSS VSS VDD VDD _01877_ _01878_ sky130_fd_sc_hd__ha_1
X_10537_ net455 _05525_ VSS VSS VDD VDD _01879_ _01880_ sky130_fd_sc_hd__ha_1
X_10538_ net456 _05521_ VSS VSS VDD VDD _01881_ _01882_ sky130_fd_sc_hd__ha_1
X_10539_ net452 net451 VSS VSS VDD VDD _05213_ _05737_ sky130_fd_sc_hd__ha_1
X_10540_ net454 _05737_ VSS VSS VDD VDD _05216_ _01883_ sky130_fd_sc_hd__ha_1
X_10541_ stage3_in_r\[78\] _05164_ VSS VSS VDD VDD _00557_
+ _01884_ sky130_fd_sc_hd__ha_1
X_10542_ _05177_ _01885_ VSS VSS VDD VDD _05738_ _05739_ sky130_fd_sc_hd__ha_1
X_10543_ _05697_ _05739_ VSS VSS VDD VDD _01886_ _01887_ sky130_fd_sc_hd__ha_1
X_10544_ net451 stage3_in_r\[71\] VSS VSS VDD VDD _05221_
+ _05740_ sky130_fd_sc_hd__ha_1
X_10545_ net453 _05740_ VSS VSS VDD VDD _05224_ _05217_ sky130_fd_sc_hd__ha_1
X_10546_ stage3_in_r\[78\] _05207_ VSS VSS VDD VDD _00568_
+ _01888_ sky130_fd_sc_hd__ha_1
X_10547_ _01889_ _01890_ VSS VSS VDD VDD _05741_ _05742_ sky130_fd_sc_hd__ha_1
X_10548_ _05738_ _05742_ VSS VSS VDD VDD _01891_ _01892_ sky130_fd_sc_hd__ha_1
X_10549_ stage3_in_r\[71\] stage3_in_r\[72\] VSS VSS VDD VDD
+ _05228_ _05743_ sky130_fd_sc_hd__ha_1
X_10550_ net452 _05743_ VSS VSS VDD VDD _05231_ _05225_ sky130_fd_sc_hd__ha_1
X_10551_ stage3_in_r\[78\] _05214_ VSS VSS VDD VDD _05233_
+ _01893_ sky130_fd_sc_hd__ha_1
X_10552_ _01894_ _01895_ VSS VSS VDD VDD _05744_ _05745_ sky130_fd_sc_hd__ha_1
X_10553_ _05741_ _05745_ VSS VSS VDD VDD _01896_ _01897_ sky130_fd_sc_hd__ha_1
X_10554_ stage3_in_r\[72\] net450 VSS VSS VDD VDD _05237_
+ _05746_ sky130_fd_sc_hd__ha_1
X_10555_ net451 _05746_ VSS VSS VDD VDD _05240_ _05232_ sky130_fd_sc_hd__ha_1
X_10556_ stage3_in_r\[78\] _05222_ VSS VSS VDD VDD _05242_
+ _01898_ sky130_fd_sc_hd__ha_1
X_10557_ _01899_ _05235_ VSS VSS VDD VDD _05747_ _05748_ sky130_fd_sc_hd__ha_1
X_10558_ _05744_ _05748_ VSS VSS VDD VDD _01900_ _01901_ sky130_fd_sc_hd__ha_1
X_10559_ stage3_in_r\[197\] _01902_ VSS VSS VDD VDD _01903_
+ _01904_ sky130_fd_sc_hd__ha_2
X_10560_ stage3_in_r\[197\] _01905_ VSS VSS VDD VDD _01906_
+ _05749_ sky130_fd_sc_hd__ha_1
X_10561_ net450 net449 VSS VSS VDD VDD _00686_ _00701_ sky130_fd_sc_hd__ha_1
X_10562_ stage3_in_r\[71\] _00701_ VSS VSS VDD VDD _05245_
+ _05241_ sky130_fd_sc_hd__ha_1
X_10563_ stage3_in_r\[78\] _05229_ VSS VSS VDD VDD _05247_
+ _01907_ sky130_fd_sc_hd__ha_1
X_10564_ _05234_ _05244_ VSS VSS VDD VDD _05750_ _05751_ sky130_fd_sc_hd__ha_1
X_10565_ _05747_ _05751_ VSS VSS VDD VDD _01908_ _01909_ sky130_fd_sc_hd__ha_1
X_10566_ stage3_in_r\[198\] _01910_ VSS VSS VDD VDD _01911_
+ _01912_ sky130_fd_sc_hd__ha_2
X_10567_ stage3_in_r\[198\] _01913_ VSS VSS VDD VDD _01914_
+ _05752_ sky130_fd_sc_hd__ha_1
X_10568_ net449 net448 VSS VSS VDD VDD _05753_ _05754_ sky130_fd_sc_hd__ha_1
X_10569_ stage3_in_r\[72\] _05754_ VSS VSS VDD VDD _05251_
+ _05246_ sky130_fd_sc_hd__ha_1
X_10570_ stage3_in_r\[78\] _05238_ VSS VSS VDD VDD _05253_
+ _01917_ sky130_fd_sc_hd__ha_1
X_10571_ _05243_ _05249_ VSS VSS VDD VDD _05755_ _05756_ sky130_fd_sc_hd__ha_1
X_10572_ _05750_ _05756_ VSS VSS VDD VDD _01918_ _01919_ sky130_fd_sc_hd__ha_1
X_10573_ stage3_in_r\[199\] _01920_ VSS VSS VDD VDD _01921_
+ _01922_ sky130_fd_sc_hd__ha_1
X_10574_ stage3_in_r\[199\] _01923_ VSS VSS VDD VDD _01924_
+ _05757_ sky130_fd_sc_hd__ha_1
X_10575_ net448 stage3_in_r\[76\] VSS VSS VDD VDD _01925_
+ _05758_ sky130_fd_sc_hd__ha_1
X_10576_ net450 _05758_ VSS VSS VDD VDD _05256_ _05252_ sky130_fd_sc_hd__ha_1
X_10577_ _01926_ _05753_ VSS VSS VDD VDD _05759_ _05250_ sky130_fd_sc_hd__ha_1
X_10578_ net446 _01927_ VSS VSS VDD VDD _05258_ _01928_ sky130_fd_sc_hd__ha_1
X_10579_ _05248_ _05255_ VSS VSS VDD VDD _05760_ _05761_ sky130_fd_sc_hd__ha_1
X_10580_ _05755_ _05761_ VSS VSS VDD VDD _01929_ _01930_ sky130_fd_sc_hd__ha_1
X_10581_ stage3_in_r\[200\] _01931_ VSS VSS VDD VDD _01932_
+ _01933_ sky130_fd_sc_hd__ha_1
X_10582_ stage3_in_r\[200\] _01934_ VSS VSS VDD VDD _01935_
+ _05762_ sky130_fd_sc_hd__ha_1
X_10583_ stage3_in_r\[76\] stage3_in_r\[77\] VSS VSS VDD VDD
+ _01936_ _01937_ sky130_fd_sc_hd__ha_1
X_10584_ net449 _01937_ VSS VSS VDD VDD _05262_ _05257_ sky130_fd_sc_hd__ha_1
X_10585_ net446 _01938_ VSS VSS VDD VDD _01939_ _01940_ sky130_fd_sc_hd__ha_1
X_10586_ net446 _01925_ VSS VSS VDD VDD _05268_ _05763_ sky130_fd_sc_hd__ha_1
X_10587_ net446 _05759_ VSS VSS VDD VDD _05264_ _01941_ sky130_fd_sc_hd__ha_1
X_10588_ _05254_ _05260_ VSS VSS VDD VDD _05764_ _05765_ sky130_fd_sc_hd__ha_1
X_10589_ _05760_ _05765_ VSS VSS VDD VDD _01942_ _01943_ sky130_fd_sc_hd__ha_1
X_10590_ net448 _01915_ VSS VSS VDD VDD _01944_ _05263_ sky130_fd_sc_hd__ha_1
X_10591_ net446 _01936_ VSS VSS VDD VDD _05272_ _05261_ sky130_fd_sc_hd__ha_1
X_10592_ net446 _01945_ VSS VSS VDD VDD _01946_ _05766_ sky130_fd_sc_hd__ha_1
X_10593_ _05259_ _05266_ VSS VSS VDD VDD _05767_ _05768_ sky130_fd_sc_hd__ha_1
X_10594_ _05764_ _05768_ VSS VSS VDD VDD _01947_ _01948_ sky130_fd_sc_hd__ha_1
X_10595_ _05265_ _05270_ VSS VSS VDD VDD _05769_ _05770_ sky130_fd_sc_hd__ha_1
X_10596_ _05767_ _05770_ VSS VSS VDD VDD _01949_ _01950_ sky130_fd_sc_hd__ha_1
X_10597_ _05269_ _05274_ VSS VSS VDD VDD _05771_ _05772_ sky130_fd_sc_hd__ha_1
X_10598_ _05769_ _05772_ VSS VSS VDD VDD _01951_ _01952_ sky130_fd_sc_hd__ha_1
X_10599_ _05273_ _01954_ VSS VSS VDD VDD _05773_ _05774_ sky130_fd_sc_hd__ha_1
X_10600_ _05771_ _05774_ VSS VSS VDD VDD _01955_ _01956_ sky130_fd_sc_hd__ha_1
X_10601_ _01957_ _01756_ VSS VSS VDD VDD _01958_ _01959_ sky130_fd_sc_hd__ha_1
X_10602_ _05773_ _01960_ VSS VSS VDD VDD _01961_ _01962_ sky130_fd_sc_hd__ha_1
X_10603_ _01963_ _01536_ VSS VSS VDD VDD _01964_ _01965_ sky130_fd_sc_hd__ha_1
X_10604_ _01966_ stage3_in_r\[206\] VSS VSS VDD VDD _01967_
+ _01968_ sky130_fd_sc_hd__ha_1
X_10605_ stage3_in_r\[193\] _01095_ VSS VSS VDD VDD _01969_
+ _01970_ sky130_fd_sc_hd__ha_1
X_10606_ stage3_in_r\[193\] _01104_ VSS VSS VDD VDD _01971_
+ _05775_ sky130_fd_sc_hd__ha_1
X_10607_ stage3_in_r\[194\] _01972_ VSS VSS VDD VDD _01973_
+ _01974_ sky130_fd_sc_hd__ha_1
X_10608_ stage3_in_r\[194\] _01975_ VSS VSS VDD VDD _01976_
+ _05776_ sky130_fd_sc_hd__ha_1
X_10609_ stage3_in_r\[195\] _01977_ VSS VSS VDD VDD _01978_
+ _01979_ sky130_fd_sc_hd__ha_1
X_10610_ stage3_in_r\[195\] _01980_ VSS VSS VDD VDD _01981_
+ _05777_ sky130_fd_sc_hd__ha_1
X_10611_ stage3_in_r\[196\] _01982_ VSS VSS VDD VDD _01983_
+ _01984_ sky130_fd_sc_hd__ha_1
X_10612_ stage3_in_r\[196\] _01985_ VSS VSS VDD VDD _01986_
+ _05778_ sky130_fd_sc_hd__ha_1
X_10613_ stage3_in_r\[201\] _01987_ VSS VSS VDD VDD _01988_
+ _01989_ sky130_fd_sc_hd__ha_1
X_10614_ stage3_in_r\[201\] _01990_ VSS VSS VDD VDD _01991_
+ _05779_ sky130_fd_sc_hd__ha_1
X_10615_ stage3_in_r\[202\] _01992_ VSS VSS VDD VDD _01993_
+ _01994_ sky130_fd_sc_hd__ha_1
X_10616_ stage3_in_r\[202\] _01995_ VSS VSS VDD VDD _01996_
+ _05780_ sky130_fd_sc_hd__ha_1
X_10617_ stage3_in_r\[203\] _01997_ VSS VSS VDD VDD _01998_
+ _01999_ sky130_fd_sc_hd__ha_1
X_10618_ stage3_in_r\[203\] _02000_ VSS VSS VDD VDD _02001_
+ _05781_ sky130_fd_sc_hd__ha_1
X_10619_ stage3_in_r\[204\] _02002_ VSS VSS VDD VDD _02003_
+ _02004_ sky130_fd_sc_hd__ha_1
X_10620_ stage3_in_r\[204\] _02005_ VSS VSS VDD VDD _02006_
+ _05782_ sky130_fd_sc_hd__ha_1
X_10621_ stage3_in_r\[205\] _02007_ VSS VSS VDD VDD _02008_
+ _02009_ sky130_fd_sc_hd__ha_1
X_10622_ stage3_in_r\[205\] _02010_ VSS VSS VDD VDD _02011_
+ _05783_ sky130_fd_sc_hd__ha_1
X_10623_ stage3_in_r\[206\] _02012_ VSS VSS VDD VDD _02013_
+ _02014_ sky130_fd_sc_hd__ha_1
X_10624_ stage3_in_r\[206\] _02015_ VSS VSS VDD VDD _02016_
+ _05784_ sky130_fd_sc_hd__ha_1
X_10625_ stage3_in_r\[206\] _01966_ VSS VSS VDD VDD _05785_
+ _02017_ sky130_fd_sc_hd__ha_1
X_10626_ stage3_in_r\[206\] _02018_ VSS VSS VDD VDD _02019_
+ _05786_ sky130_fd_sc_hd__ha_1
X_10627_ net444 _05506_ VSS VSS VDD VDD _02020_ _02021_ sky130_fd_sc_hd__ha_1
X_10628_ _00042_ net437 VSS VSS VDD VDD _01404_ _01382_ sky130_fd_sc_hd__ha_1
X_10629_ net439 net437 VSS VSS VDD VDD _05381_ _05787_ sky130_fd_sc_hd__ha_1
X_10630_ stage3_in_r\[17\] _05511_ VSS VSS VDD VDD _02022_
+ _02023_ sky130_fd_sc_hd__ha_1
X_10631_ _00034_ net438 VSS VSS VDD VDD _01381_ _05120_ sky130_fd_sc_hd__ha_1
X_10632_ net440 net438 VSS VSS VDD VDD _05275_ _05788_ sky130_fd_sc_hd__ha_1
X_10633_ net432 _02025_ VSS VSS VDD VDD _00832_ _02026_ sky130_fd_sc_hd__ha_1
X_10634_ net445 _05515_ VSS VSS VDD VDD _02024_ _05789_ sky130_fd_sc_hd__ha_1
X_10635_ net432 _05285_ VSS VSS VDD VDD _05287_ _05291_ sky130_fd_sc_hd__ha_1
X_10636_ _05789_ _05286_ VSS VSS VDD VDD _05292_ _05300_ sky130_fd_sc_hd__ha_1
X_10637_ _00082_ net440 VSS VSS VDD VDD _05107_ _05092_ sky130_fd_sc_hd__ha_1
X_10638_ net442 net440 VSS VSS VDD VDD _05283_ _05790_ sky130_fd_sc_hd__ha_1
X_10639_ stage3_in_r\[29\] _02028_ VSS VSS VDD VDD _05294_
+ _05298_ sky130_fd_sc_hd__ha_1
X_10640_ _05296_ _05290_ VSS VSS VDD VDD _05791_ _05792_ sky130_fd_sc_hd__ha_1
X_10641_ _02029_ _05518_ VSS VSS VDD VDD _05299_ _05308_ sky130_fd_sc_hd__ha_1
X_10642_ _00091_ net441 VSS VSS VDD VDD _05091_ _00305_ sky130_fd_sc_hd__ha_1
X_10643_ net443 net441 VSS VSS VDD VDD _02027_ _05793_ sky130_fd_sc_hd__ha_1
X_10644_ _02030_ _04939_ VSS VSS VDD VDD _05794_ _05795_ sky130_fd_sc_hd__ha_1
X_10645_ net434 _05794_ VSS VSS VDD VDD _05302_ _05306_ sky130_fd_sc_hd__ha_1
X_10646_ _05796_ _05792_ VSS VSS VDD VDD _02031_ _02032_ sky130_fd_sc_hd__ha_1
X_10647_ _05304_ _05297_ VSS VSS VDD VDD _05796_ _05797_ sky130_fd_sc_hd__ha_1
X_10648_ _05795_ _05521_ VSS VSS VDD VDD _05307_ _02033_ sky130_fd_sc_hd__ha_1
X_10649_ net435 _05508_ VSS VSS VDD VDD _05310_ _02034_ sky130_fd_sc_hd__ha_1
X_10650_ _05798_ _05797_ VSS VSS VDD VDD _02036_ _02037_ sky130_fd_sc_hd__ha_1
X_10651_ _05311_ _05305_ VSS VSS VDD VDD _05798_ _05799_ sky130_fd_sc_hd__ha_1
X_10652_ net436 _05513_ VSS VSS VDD VDD _02038_ _05800_ sky130_fd_sc_hd__ha_1
X_10653_ net445 _05509_ VSS VSS VDD VDD _02035_ _05801_ sky130_fd_sc_hd__ha_1
X_10654_ _05802_ _05799_ VSS VSS VDD VDD _02040_ _02041_ sky130_fd_sc_hd__ha_1
X_10655_ _02042_ _05312_ VSS VSS VDD VDD _05802_ _05803_ sky130_fd_sc_hd__ha_1
X_10656_ _05801_ _05800_ VSS VSS VDD VDD _02039_ _05804_ sky130_fd_sc_hd__ha_1
X_10657_ _05805_ _05803_ VSS VSS VDD VDD _02043_ _02044_ sky130_fd_sc_hd__ha_1
X_10658_ _05806_ _02045_ VSS VSS VDD VDD _05805_ _05807_ sky130_fd_sc_hd__ha_1
X_10659_ _05808_ _05804_ VSS VSS VDD VDD _05806_ _05809_ sky130_fd_sc_hd__ha_1
X_10660_ net437 _05514_ VSS VSS VDD VDD _05808_ _05810_ sky130_fd_sc_hd__ha_1
X_10661_ _05811_ _05807_ VSS VSS VDD VDD _02046_ _02047_ sky130_fd_sc_hd__ha_1
X_10662_ _05812_ _05809_ VSS VSS VDD VDD _05811_ _02048_ sky130_fd_sc_hd__ha_1
X_10663_ _05813_ _05810_ VSS VSS VDD VDD _05812_ _05814_ sky130_fd_sc_hd__ha_1
X_10664_ net438 _01131_ VSS VSS VDD VDD _05813_ _05815_ sky130_fd_sc_hd__ha_1
X_10665_ _02049_ _02048_ VSS VSS VDD VDD _02050_ _02051_ sky130_fd_sc_hd__ha_1
X_10666_ _05816_ _05814_ VSS VSS VDD VDD _02049_ _05817_ sky130_fd_sc_hd__ha_1
X_10667_ _05818_ _05815_ VSS VSS VDD VDD _05816_ _05819_ sky130_fd_sc_hd__ha_1
X_10668_ stage3_in_r\[17\] net439 VSS VSS VDD VDD _05818_
+ _05820_ sky130_fd_sc_hd__ha_1
X_10669_ _02052_ net454 VSS VSS VDD VDD _05388_ _00680_ sky130_fd_sc_hd__ha_1
X_10670_ stage3_in_r\[65\] net454 VSS VSS VDD VDD _01828_
+ _05821_ sky130_fd_sc_hd__ha_1
X_10671_ stage3_in_r\[72\] _01819_ VSS VSS VDD VDD _02053_
+ _02054_ sky130_fd_sc_hd__ha_1
X_10672_ _02056_ _05319_ VSS VSS VDD VDD _05822_ _02057_ sky130_fd_sc_hd__ha_1
X_10673_ stage3_in_r\[65\] net453 VSS VSS VDD VDD _02055_
+ _02058_ sky130_fd_sc_hd__ha_1
X_10674_ _05327_ _02060_ VSS VSS VDD VDD _05823_ _05325_ sky130_fd_sc_hd__ha_1
X_10675_ _00688_ _05823_ VSS VSS VDD VDD _00846_ _02061_ sky130_fd_sc_hd__ha_1
X_10676_ stage3_in_r\[64\] net454 VSS VSS VDD VDD _02059_
+ _05824_ sky130_fd_sc_hd__ha_1
X_10677_ _05334_ _05328_ VSS VSS VDD VDD _02062_ _05331_ sky130_fd_sc_hd__ha_1
X_10678_ net452 _05824_ VSS VSS VDD VDD _05332_ _05339_ sky130_fd_sc_hd__ha_1
X_10679_ _05342_ _05335_ VSS VSS VDD VDD _05825_ _05338_ sky130_fd_sc_hd__ha_1
X_10680_ _05317_ _05825_ VSS VSS VDD VDD _02063_ _05336_ sky130_fd_sc_hd__ha_1
X_10681_ _02064_ _02065_ VSS VSS VDD VDD _02066_ _02067_ sky130_fd_sc_hd__ha_1
X_10682_ _05346_ _05343_ VSS VSS VDD VDD _05826_ _02068_ sky130_fd_sc_hd__ha_1
X_10683_ _02069_ _05826_ VSS VSS VDD VDD _02070_ _05344_ sky130_fd_sc_hd__ha_1
X_10684_ _05353_ _05347_ VSS VSS VDD VDD _05827_ _02071_ sky130_fd_sc_hd__ha_1
X_10685_ _05827_ _00700_ VSS VSS VDD VDD _05348_ _05352_ sky130_fd_sc_hd__ha_1
X_10686_ _05350_ _02072_ VSS VSS VDD VDD _02073_ _02074_ sky130_fd_sc_hd__ha_1
X_10687_ _05359_ _05354_ VSS VSS VDD VDD _05828_ _05829_ sky130_fd_sc_hd__ha_1
X_10688_ _05828_ _00716_ VSS VSS VDD VDD _02075_ _05355_ sky130_fd_sc_hd__ha_1
X_10689_ _02076_ _05351_ VSS VSS VDD VDD _02077_ _02078_ sky130_fd_sc_hd__ha_1
X_10690_ _05829_ _01844_ VSS VSS VDD VDD _05356_ _05367_ sky130_fd_sc_hd__ha_1
X_10691_ _02079_ _05360_ VSS VSS VDD VDD _05830_ _05831_ sky130_fd_sc_hd__ha_1
X_10692_ _05830_ _00731_ VSS VSS VDD VDD _05361_ _05365_ sky130_fd_sc_hd__ha_1
X_10693_ _02080_ _02081_ VSS VSS VDD VDD _02082_ _02083_ sky130_fd_sc_hd__ha_1
X_10694_ _05363_ _02084_ VSS VSS VDD VDD _02085_ _02086_ sky130_fd_sc_hd__ha_1
X_10695_ stage3_in_r\[65\] _05831_ VSS VSS VDD VDD _05366_
+ _02087_ sky130_fd_sc_hd__ha_1
X_10696_ _05374_ _02088_ VSS VSS VDD VDD _05832_ _05833_ sky130_fd_sc_hd__ha_1
X_10697_ _05832_ _00746_ VSS VSS VDD VDD _05370_ _02089_ sky130_fd_sc_hd__ha_1
X_10698_ _05371_ _05364_ VSS VSS VDD VDD _02091_ _02092_ sky130_fd_sc_hd__ha_1
X_10699_ _00799_ _00524_ VSS VSS VDD VDD _05834_ _02093_ sky130_fd_sc_hd__ha_1
X_10700_ _05835_ _00763_ VSS VSS VDD VDD _05376_ _05836_ sky130_fd_sc_hd__ha_1
X_10701_ stage3_in_r\[64\] _05833_ VSS VSS VDD VDD _02090_
+ _05837_ sky130_fd_sc_hd__ha_1
X_10702_ _05378_ _05372_ VSS VSS VDD VDD _02094_ _02095_ sky130_fd_sc_hd__ha_1
X_10703_ _05837_ _05836_ VSS VSS VDD VDD _05377_ _02096_ sky130_fd_sc_hd__ha_1
X_10704_ _05838_ _00774_ VSS VSS VDD VDD _02097_ _05839_ sky130_fd_sc_hd__ha_1
X_10705_ _05375_ _02098_ VSS VSS VDD VDD _05835_ _05840_ sky130_fd_sc_hd__ha_1
X_10706_ _02100_ _05379_ VSS VSS VDD VDD _02101_ _02102_ sky130_fd_sc_hd__ha_1
X_10707_ _05840_ _05839_ VSS VSS VDD VDD _02099_ _02103_ sky130_fd_sc_hd__ha_1
X_10708_ _00787_ _01824_ VSS VSS VDD VDD _05841_ _05842_ sky130_fd_sc_hd__ha_1
X_10709_ _05843_ _05358_ VSS VSS VDD VDD _02104_ _05844_ sky130_fd_sc_hd__ha_1
X_10710_ _02105_ _05841_ VSS VSS VDD VDD _05838_ _05845_ sky130_fd_sc_hd__ha_1
X_10711_ _02107_ _02108_ VSS VSS VDD VDD _02109_ _02110_ sky130_fd_sc_hd__ha_1
X_10712_ _05845_ _05844_ VSS VSS VDD VDD _02106_ _05846_ sky130_fd_sc_hd__ha_1
X_10713_ _05842_ _05847_ VSS VSS VDD VDD _05843_ _05848_ sky130_fd_sc_hd__ha_1
X_10714_ _05849_ _02111_ VSS VSS VDD VDD _02112_ _02113_ sky130_fd_sc_hd__ha_1
X_10715_ _05850_ _05846_ VSS VSS VDD VDD _05849_ _02114_ sky130_fd_sc_hd__ha_1
X_10716_ _05848_ _00792_ VSS VSS VDD VDD _05850_ _05851_ sky130_fd_sc_hd__ha_1
X_10717_ stage3_in_r\[64\] _05369_ VSS VSS VDD VDD _05847_
+ _05852_ sky130_fd_sc_hd__ha_1
X_10718_ _02115_ _02114_ VSS VSS VDD VDD _02116_ _02117_ sky130_fd_sc_hd__ha_1
X_10719_ _05853_ _05851_ VSS VSS VDD VDD _02115_ _05854_ sky130_fd_sc_hd__ha_1
X_10720_ _05852_ _05373_ VSS VSS VDD VDD _05853_ _05855_ sky130_fd_sc_hd__ha_1
X_10721_ _02118_ _02119_ VSS VSS VDD VDD _02120_ _02121_ sky130_fd_sc_hd__ha_1
X_10722_ _02122_ _02123_ VSS VSS VDD VDD _02124_ _02125_ sky130_fd_sc_hd__ha_1
X_10723_ _02126_ _02127_ VSS VSS VDD VDD _02128_ _02129_ sky130_fd_sc_hd__ha_1
X_10724_ _02130_ _02131_ VSS VSS VDD VDD _02132_ _02133_ sky130_fd_sc_hd__ha_1
X_10725_ _02134_ _02135_ VSS VSS VDD VDD _02136_ _02137_ sky130_fd_sc_hd__ha_1
X_10726_ _02139_ _02140_ VSS VSS VDD VDD _02141_ _02142_ sky130_fd_sc_hd__ha_1
X_10727_ _05856_ _05817_ VSS VSS VDD VDD _02138_ _05857_ sky130_fd_sc_hd__ha_1
X_10728_ _02143_ _05857_ VSS VSS VDD VDD _02144_ _02145_ sky130_fd_sc_hd__ha_1
X_10729_ _05858_ _05819_ VSS VSS VDD VDD _05856_ _05859_ sky130_fd_sc_hd__ha_1
X_10730_ _02146_ _05859_ VSS VSS VDD VDD _02147_ _02148_ sky130_fd_sc_hd__ha_1
X_10731_ _05860_ _05820_ VSS VSS VDD VDD _05858_ _05861_ sky130_fd_sc_hd__ha_1
X_10732_ _02149_ _05861_ VSS VSS VDD VDD _02150_ _02151_ sky130_fd_sc_hd__ha_1
X_10733_ net445 net440 VSS VSS VDD VDD _05860_ _05862_ sky130_fd_sc_hd__ha_1
X_10734_ _02152_ _05862_ VSS VSS VDD VDD _02153_ _02154_ sky130_fd_sc_hd__ha_1
X_10735_ net441 _05380_ VSS VSS VDD VDD _02156_ _02157_ sky130_fd_sc_hd__ha_1
X_10736_ _05863_ _05854_ VSS VSS VDD VDD _02155_ _02158_ sky130_fd_sc_hd__ha_1
X_10737_ net442 _02159_ VSS VSS VDD VDD _02160_ _02161_ sky130_fd_sc_hd__ha_1
X_10738_ _05855_ _05834_ VSS VSS VDD VDD _05863_ _02162_ sky130_fd_sc_hd__ha_1
X_10739_ net443 _02163_ VSS VSS VDD VDD _02164_ _02165_ sky130_fd_sc_hd__ha_1
X_10740_ net444 _02166_ VSS VSS VDD VDD _02167_ _02168_ sky130_fd_sc_hd__ha_1
X_10741_ stage3_in_r\[17\] _02169_ VSS VSS VDD VDD _02170_
+ _02171_ sky130_fd_sc_hd__ha_1
X_10742_ net443 _05504_ VSS VSS VDD VDD _05400_ _02172_ sky130_fd_sc_hd__ha_1
X_10743_ _00025_ net436 VSS VSS VDD VDD _05151_ _01405_ sky130_fd_sc_hd__ha_1
X_10744_ net438 net436 VSS VSS VDD VDD _05396_ _05864_ sky130_fd_sc_hd__ha_1
X_10745_ net432 _05277_ VSS VSS VDD VDD _00855_ _02173_ sky130_fd_sc_hd__ha_1
X_10746_ _05289_ _02174_ VSS VSS VDD VDD _05865_ _05866_ sky130_fd_sc_hd__ha_1
X_10747_ _05791_ _05866_ VSS VSS VDD VDD _02175_ _02176_ sky130_fd_sc_hd__ha_1
X_10748_ _02177_ net453 VSS VSS VDD VDD _05404_ _00760_ sky130_fd_sc_hd__ha_1
X_10749_ net455 net453 VSS VSS VDD VDD _05340_ _05867_ sky130_fd_sc_hd__ha_1
X_10750_ _02178_ _05822_ VSS VSS VDD VDD _00869_ _02179_ sky130_fd_sc_hd__ha_1
X_10751_ _02180_ _02181_ VSS VSS VDD VDD _02182_ _02183_ sky130_fd_sc_hd__ha_1
X_10752_ _02184_ _02185_ VSS VSS VDD VDD _02186_ _02187_ sky130_fd_sc_hd__ha_1
X_10753_ net442 _05503_ VSS VSS VDD VDD _05417_ _05401_ sky130_fd_sc_hd__ha_1
X_10754_ _00026_ net435 VSS VSS VDD VDD _05154_ _00436_ sky130_fd_sc_hd__ha_1
X_10755_ net437 net435 VSS VSS VDD VDD _05413_ _05868_ sky130_fd_sc_hd__ha_1
X_10756_ net432 _05383_ VSS VSS VDD VDD _00880_ _02188_ sky130_fd_sc_hd__ha_1
X_10757_ _02189_ _02190_ VSS VSS VDD VDD _05869_ _05870_ sky130_fd_sc_hd__ha_1
X_10758_ _05865_ _05870_ VSS VSS VDD VDD _02191_ _02192_ sky130_fd_sc_hd__ha_1
X_10759_ _00776_ net452 VSS VSS VDD VDD _05420_ _00856_ sky130_fd_sc_hd__ha_1
X_10760_ net454 net452 VSS VSS VDD VDD _05182_ _05871_ sky130_fd_sc_hd__ha_1
X_10761_ _00835_ _02193_ VSS VSS VDD VDD _02194_ _02195_ sky130_fd_sc_hd__ha_1
X_10762_ net447 _02196_ VSS VSS VDD VDD _00891_ _02197_ sky130_fd_sc_hd__ha_1
X_10763_ _02198_ _02199_ VSS VSS VDD VDD _02200_ _02201_ sky130_fd_sc_hd__ha_1
X_10764_ _02202_ _02203_ VSS VSS VDD VDD _02204_ _02205_ sky130_fd_sc_hd__ha_1
X_10765_ net441 _05500_ VSS VSS VDD VDD _05431_ _05418_ sky130_fd_sc_hd__ha_1
X_10766_ _00027_ net434 VSS VSS VDD VDD _05157_ _00455_ sky130_fd_sc_hd__ha_1
X_10767_ net436 net434 VSS VSS VDD VDD _05427_ _05872_ sky130_fd_sc_hd__ha_1
X_10768_ net432 _05398_ VSS VSS VDD VDD _05433_ _02206_ sky130_fd_sc_hd__ha_1
X_10769_ _02207_ _02208_ VSS VSS VDD VDD _05873_ _05874_ sky130_fd_sc_hd__ha_1
X_10770_ _05869_ _05874_ VSS VSS VDD VDD _02209_ _02210_ sky130_fd_sc_hd__ha_1
X_10771_ _00765_ net451 VSS VSS VDD VDD _05436_ _00881_ sky130_fd_sc_hd__ha_1
X_10772_ net453 net451 VSS VSS VDD VDD _05171_ _05875_ sky130_fd_sc_hd__ha_1
X_10773_ _02211_ _05407_ VSS VSS VDD VDD _02212_ _02213_ sky130_fd_sc_hd__ha_1
X_10774_ _02214_ _02215_ VSS VSS VDD VDD _02216_ _02217_ sky130_fd_sc_hd__ha_1
X_10775_ _02218_ _02219_ VSS VSS VDD VDD _02220_ _02221_ sky130_fd_sc_hd__ha_1
X_10776_ net440 _05497_ VSS VSS VDD VDD _05446_ _05432_ sky130_fd_sc_hd__ha_1
X_10777_ _00059_ stage3_in_r\[29\] VSS VSS VDD VDD _02222_
+ _00468_ sky130_fd_sc_hd__ha_1
X_10778_ net435 net433 VSS VSS VDD VDD _05442_ _05876_ sky130_fd_sc_hd__ha_1
X_10779_ net432 _05415_ VSS VSS VDD VDD _05448_ _02223_ sky130_fd_sc_hd__ha_1
X_10780_ _02224_ _05435_ VSS VSS VDD VDD _05877_ _05878_ sky130_fd_sc_hd__ha_1
X_10781_ _05873_ _05878_ VSS VSS VDD VDD _02225_ _02226_ sky130_fd_sc_hd__ha_1
X_10782_ _00748_ stage3_in_r\[71\] VSS VSS VDD VDD _05451_
+ _00693_ sky130_fd_sc_hd__ha_1
X_10783_ net452 stage3_in_r\[71\] VSS VSS VDD VDD _01819_
+ _05879_ sky130_fd_sc_hd__ha_1
X_10784_ net447 _02178_ VSS VSS VDD VDD _02227_ _02228_ sky130_fd_sc_hd__ha_1
X_10785_ net447 _02229_ VSS VSS VDD VDD _02230_ _05880_ sky130_fd_sc_hd__ha_1
X_10786_ _02231_ _02232_ VSS VSS VDD VDD _02233_ _02234_ sky130_fd_sc_hd__ha_1
X_10787_ _02235_ _02236_ VSS VSS VDD VDD _02237_ _02238_ sky130_fd_sc_hd__ha_1
X_10788_ _02239_ _02240_ VSS VSS VDD VDD _02241_ _02242_ sky130_fd_sc_hd__ha_1
X_10789_ stage3_in_r\[149\] _02243_ VSS VSS VDD VDD _02244_
+ _02245_ sky130_fd_sc_hd__ha_1
X_10790_ stage3_in_r\[149\] _02246_ VSS VSS VDD VDD _02247_
+ _05881_ sky130_fd_sc_hd__ha_1
X_10791_ net439 _00024_ VSS VSS VDD VDD _05457_ _05447_ sky130_fd_sc_hd__ha_1
X_10792_ _00308_ net431 VSS VSS VDD VDD _02248_ _02249_ sky130_fd_sc_hd__ha_1
X_10793_ net434 net431 VSS VSS VDD VDD _02250_ _05882_ sky130_fd_sc_hd__ha_1
X_10794_ net431 _05429_ VSS VSS VDD VDD _05459_ _02251_ sky130_fd_sc_hd__ha_1
X_10795_ _05434_ _05450_ VSS VSS VDD VDD _05883_ _05884_ sky130_fd_sc_hd__ha_1
X_10796_ _05877_ _05884_ VSS VSS VDD VDD _02252_ _02253_ sky130_fd_sc_hd__ha_1
X_10797_ _00711_ stage3_in_r\[72\] VSS VSS VDD VDD _02254_
+ _05167_ sky130_fd_sc_hd__ha_1
X_10798_ net451 stage3_in_r\[72\] VSS VSS VDD VDD _05162_
+ _05885_ sky130_fd_sc_hd__ha_1
X_10799_ net447 _02255_ VSS VSS VDD VDD _00975_ _02256_ sky130_fd_sc_hd__ha_1
X_10800_ net447 _02257_ VSS VSS VDD VDD _02258_ _05886_ sky130_fd_sc_hd__ha_1
X_10801_ _02259_ _02260_ VSS VSS VDD VDD _02261_ _02262_ sky130_fd_sc_hd__ha_1
X_10802_ _02263_ _02264_ VSS VSS VDD VDD _02265_ _02266_ sky130_fd_sc_hd__ha_1
X_10803_ stage3_in_r\[150\] _02267_ VSS VSS VDD VDD _02268_
+ _02269_ sky130_fd_sc_hd__ha_1
X_10804_ stage3_in_r\[150\] _02270_ VSS VSS VDD VDD _02271_
+ _05887_ sky130_fd_sc_hd__ha_1
X_10805_ net438 _05496_ VSS VSS VDD VDD _05466_ _05458_ sky130_fd_sc_hd__ha_1
X_10806_ net431 _05444_ VSS VSS VDD VDD _05468_ _02273_ sky130_fd_sc_hd__ha_1
X_10807_ _05449_ _05461_ VSS VSS VDD VDD _05888_ _05889_ sky130_fd_sc_hd__ha_1
X_10808_ _05883_ _05889_ VSS VSS VDD VDD _02274_ _02275_ sky130_fd_sc_hd__ha_1
X_10809_ _00719_ net450 VSS VSS VDD VDD _02276_ _02277_ sky130_fd_sc_hd__ha_1
X_10810_ stage3_in_r\[71\] net450 VSS VSS VDD VDD _05205_
+ _05890_ sky130_fd_sc_hd__ha_1
X_10811_ _02278_ _02279_ VSS VSS VDD VDD _05891_ _02280_ sky130_fd_sc_hd__ha_1
X_10812_ _02281_ _02282_ VSS VSS VDD VDD _02283_ _02284_ sky130_fd_sc_hd__ha_1
X_10813_ _02285_ _02286_ VSS VSS VDD VDD _02287_ _02288_ sky130_fd_sc_hd__ha_1
X_10814_ stage3_in_r\[151\] _02289_ VSS VSS VDD VDD _02290_
+ _02291_ sky130_fd_sc_hd__ha_1
X_10815_ stage3_in_r\[151\] _02292_ VSS VSS VDD VDD _02293_
+ _05892_ sky130_fd_sc_hd__ha_1
X_10816_ net437 _05498_ VSS VSS VDD VDD _05473_ _05467_ sky130_fd_sc_hd__ha_1
X_10817_ _01493_ _05495_ VSS VSS VDD VDD _05893_ _05465_ sky130_fd_sc_hd__ha_1
X_10818_ net431 _02294_ VSS VSS VDD VDD _05475_ _02295_ sky130_fd_sc_hd__ha_1
X_10819_ _05460_ _05470_ VSS VSS VDD VDD _05894_ _05895_ sky130_fd_sc_hd__ha_1
X_10820_ _05888_ _05895_ VSS VSS VDD VDD _02296_ _02297_ sky130_fd_sc_hd__ha_1
X_10821_ _00702_ net449 VSS VSS VDD VDD _05478_ _02298_ sky130_fd_sc_hd__ha_1
X_10822_ stage3_in_r\[72\] net449 VSS VSS VDD VDD _05212_
+ _05896_ sky130_fd_sc_hd__ha_1
X_10823_ _02299_ _05472_ VSS VSS VDD VDD _05897_ _05898_ sky130_fd_sc_hd__ha_1
X_10824_ _05891_ _05898_ VSS VSS VDD VDD _02300_ _00976_ sky130_fd_sc_hd__ha_1
X_10825_ _02301_ _02302_ VSS VSS VDD VDD _02303_ _02304_ sky130_fd_sc_hd__ha_1
X_10826_ _02305_ _02306_ VSS VSS VDD VDD _02307_ _02308_ sky130_fd_sc_hd__ha_1
X_10827_ stage3_in_r\[152\] _02309_ VSS VSS VDD VDD _02310_
+ _02311_ sky130_fd_sc_hd__ha_1
X_10828_ stage3_in_r\[152\] _02312_ VSS VSS VDD VDD _02313_
+ _05899_ sky130_fd_sc_hd__ha_1
X_10829_ net436 _01299_ VSS VSS VDD VDD _05480_ _05474_ sky130_fd_sc_hd__ha_1
X_10830_ net431 _02314_ VSS VSS VDD VDD _02315_ _02316_ sky130_fd_sc_hd__ha_1
X_10831_ net431 _01133_ VSS VSS VDD VDD _05487_ _05900_ sky130_fd_sc_hd__ha_1
X_10832_ net431 _05893_ VSS VSS VDD VDD _05482_ _02317_ sky130_fd_sc_hd__ha_1
X_10833_ _05469_ _05477_ VSS VSS VDD VDD _05901_ _05902_ sky130_fd_sc_hd__ha_1
X_10834_ _05894_ _05902_ VSS VSS VDD VDD _02318_ _02319_ sky130_fd_sc_hd__ha_1
X_10835_ _00703_ net448 VSS VSS VDD VDD _05485_ _00987_ sky130_fd_sc_hd__ha_1
X_10836_ net450 net448 VSS VSS VDD VDD _05220_ _05903_ sky130_fd_sc_hd__ha_1
X_10837_ _00987_ _05478_ VSS VSS VDD VDD _05904_ _02320_ sky130_fd_sc_hd__ha_1
X_10838_ _05471_ _02321_ VSS VSS VDD VDD _05905_ _05906_ sky130_fd_sc_hd__ha_1
X_10839_ _05897_ _05906_ VSS VSS VDD VDD _02322_ _02323_ sky130_fd_sc_hd__ha_1
X_10840_ _02324_ _02325_ VSS VSS VDD VDD _02326_ _02327_ sky130_fd_sc_hd__ha_1
X_10841_ _02328_ _02329_ VSS VSS VDD VDD _02330_ _02331_ sky130_fd_sc_hd__ha_1
X_10842_ net435 _02272_ VSS VSS VDD VDD _02332_ _05481_ sky130_fd_sc_hd__ha_1
X_10843_ net431 _01298_ VSS VSS VDD VDD _05492_ _05479_ sky130_fd_sc_hd__ha_1
X_10844_ net431 _02333_ VSS VSS VDD VDD _02334_ _05907_ sky130_fd_sc_hd__ha_1
X_10845_ _05476_ _05484_ VSS VSS VDD VDD _05908_ _05909_ sky130_fd_sc_hd__ha_1
X_10846_ _05901_ _05909_ VSS VSS VDD VDD _02335_ _02336_ sky130_fd_sc_hd__ha_1
X_10847_ _00704_ stage3_in_r\[76\] VSS VSS VDD VDD _05490_
+ _01003_ sky130_fd_sc_hd__ha_1
X_10848_ net449 stage3_in_r\[76\] VSS VSS VDD VDD _05227_
+ _05910_ sky130_fd_sc_hd__ha_1
X_10849_ _01003_ _05485_ VSS VSS VDD VDD _05911_ _02337_ sky130_fd_sc_hd__ha_1
X_10850_ _02338_ _02339_ VSS VSS VDD VDD _05912_ _05913_ sky130_fd_sc_hd__ha_1
X_10851_ _05905_ _05913_ VSS VSS VDD VDD _02340_ _02341_ sky130_fd_sc_hd__ha_1
X_10852_ _02342_ _02343_ VSS VSS VDD VDD _02344_ _02345_ sky130_fd_sc_hd__ha_1
X_10853_ _02346_ _02347_ VSS VSS VDD VDD _02348_ _02349_ sky130_fd_sc_hd__ha_1
X_10854_ _05483_ _05489_ VSS VSS VDD VDD _05914_ _05915_ sky130_fd_sc_hd__ha_1
X_10855_ _05908_ _05915_ VSS VSS VDD VDD _02350_ _02351_ sky130_fd_sc_hd__ha_1
X_10856_ _00735_ stage3_in_r\[77\] VSS VSS VDD VDD _02352_
+ _01019_ sky130_fd_sc_hd__ha_1
X_10857_ net448 stage3_in_r\[77\] VSS VSS VDD VDD _05236_
+ _05916_ sky130_fd_sc_hd__ha_1
X_10858_ _01019_ _05490_ VSS VSS VDD VDD _05917_ _02353_ sky130_fd_sc_hd__ha_1
X_10859_ _02354_ _02355_ VSS VSS VDD VDD _05918_ _05919_ sky130_fd_sc_hd__ha_1
X_10860_ _05912_ _05919_ VSS VSS VDD VDD _02356_ _02357_ sky130_fd_sc_hd__ha_1
X_10861_ _02358_ _02359_ VSS VSS VDD VDD _02360_ _02361_ sky130_fd_sc_hd__ha_1
X_10862_ _02362_ _02363_ VSS VSS VDD VDD _02364_ _02365_ sky130_fd_sc_hd__ha_1
X_10863_ _05488_ _05494_ VSS VSS VDD VDD _05920_ _05921_ sky130_fd_sc_hd__ha_1
X_10864_ _05914_ _05921_ VSS VSS VDD VDD _02366_ _02367_ sky130_fd_sc_hd__ha_1
X_10865_ _00632_ net447 VSS VSS VDD VDD _02368_ _02369_ sky130_fd_sc_hd__ha_1
X_10866_ stage3_in_r\[76\] net447 VSS VSS VDD VDD _01916_
+ _05922_ sky130_fd_sc_hd__ha_1
X_10867_ _02370_ _02371_ VSS VSS VDD VDD _05923_ _05924_ sky130_fd_sc_hd__ha_1
X_10868_ _05918_ _05924_ VSS VSS VDD VDD _02372_ _02373_ sky130_fd_sc_hd__ha_1
X_10869_ _02374_ _02375_ VSS VSS VDD VDD _02376_ _02377_ sky130_fd_sc_hd__ha_1
X_10870_ _02378_ _02379_ VSS VSS VDD VDD _02380_ _02381_ sky130_fd_sc_hd__ha_1
X_10871_ _05493_ _02382_ VSS VSS VDD VDD _05925_ _05926_ sky130_fd_sc_hd__ha_1
X_10872_ _05920_ _05926_ VSS VSS VDD VDD _02383_ _02384_ sky130_fd_sc_hd__ha_1
X_10873_ _00859_ stage3_in_r\[78\] VSS VSS VDD VDD _00643_
+ _00590_ sky130_fd_sc_hd__ha_1
X_10874_ _00859_ net447 VSS VSS VDD VDD _02385_ _05927_ sky130_fd_sc_hd__ha_1
X_10875_ stage3_in_r\[77\] net447 VSS VSS VDD VDD _01926_
+ _05928_ sky130_fd_sc_hd__ha_1
X_10876_ stage3_in_r\[77\] net446 VSS VSS VDD VDD _01953_
+ _05929_ sky130_fd_sc_hd__ha_1
X_10877_ _02386_ _02387_ VSS VSS VDD VDD _05930_ _05931_ sky130_fd_sc_hd__ha_1
X_10878_ _05923_ _05931_ VSS VSS VDD VDD _02388_ _02389_ sky130_fd_sc_hd__ha_1
X_10879_ _02390_ _02391_ VSS VSS VDD VDD _02392_ _02393_ sky130_fd_sc_hd__ha_1
X_10880_ _02394_ _02395_ VSS VSS VDD VDD _02396_ _02397_ sky130_fd_sc_hd__ha_1
X_10881_ _02398_ _05925_ VSS VSS VDD VDD _02399_ _02400_ sky130_fd_sc_hd__ha_1
X_10882_ _02401_ _02402_ VSS VSS VDD VDD _02403_ _05932_ sky130_fd_sc_hd__ha_1
X_10883_ _05932_ _05930_ VSS VSS VDD VDD _02404_ _02405_ sky130_fd_sc_hd__ha_1
X_10884_ _02406_ _02407_ VSS VSS VDD VDD _02408_ _02409_ sky130_fd_sc_hd__ha_1
X_10885_ _02410_ _02411_ VSS VSS VDD VDD _02412_ _02413_ sky130_fd_sc_hd__ha_1
X_10886_ _02414_ stage3_in_r\[158\] VSS VSS VDD VDD _02415_
+ _02416_ sky130_fd_sc_hd__ha_1
X_10887_ stage3_in_r\[145\] _01100_ VSS VSS VDD VDD _02417_
+ _02418_ sky130_fd_sc_hd__ha_1
X_10888_ stage3_in_r\[145\] _01108_ VSS VSS VDD VDD _02419_
+ _05933_ sky130_fd_sc_hd__ha_1
X_10889_ stage3_in_r\[146\] _02420_ VSS VSS VDD VDD _02421_
+ _02422_ sky130_fd_sc_hd__ha_1
X_10890_ stage3_in_r\[146\] _02423_ VSS VSS VDD VDD _02424_
+ _05934_ sky130_fd_sc_hd__ha_1
X_10891_ stage3_in_r\[147\] _02425_ VSS VSS VDD VDD _02426_
+ _02427_ sky130_fd_sc_hd__ha_2
X_10892_ stage3_in_r\[147\] _02428_ VSS VSS VDD VDD _02429_
+ _05935_ sky130_fd_sc_hd__ha_1
X_10893_ stage3_in_r\[148\] _02430_ VSS VSS VDD VDD _02431_
+ _02432_ sky130_fd_sc_hd__ha_1
X_10894_ stage3_in_r\[148\] _02433_ VSS VSS VDD VDD _02434_
+ _05936_ sky130_fd_sc_hd__ha_1
X_10895_ stage3_in_r\[153\] _02435_ VSS VSS VDD VDD _02436_
+ _02437_ sky130_fd_sc_hd__ha_1
X_10896_ stage3_in_r\[153\] _02438_ VSS VSS VDD VDD _02439_
+ _05937_ sky130_fd_sc_hd__ha_1
X_10897_ stage3_in_r\[154\] _02440_ VSS VSS VDD VDD _02441_
+ _02442_ sky130_fd_sc_hd__ha_1
X_10898_ stage3_in_r\[154\] _02443_ VSS VSS VDD VDD _02444_
+ _05938_ sky130_fd_sc_hd__ha_1
X_10899_ stage3_in_r\[155\] _02445_ VSS VSS VDD VDD _02446_
+ _02447_ sky130_fd_sc_hd__ha_1
X_10900_ stage3_in_r\[155\] _02448_ VSS VSS VDD VDD _02449_
+ _05939_ sky130_fd_sc_hd__ha_1
X_10901_ stage3_in_r\[156\] _02450_ VSS VSS VDD VDD _02451_
+ _02452_ sky130_fd_sc_hd__ha_1
X_10902_ stage3_in_r\[156\] _02453_ VSS VSS VDD VDD _02454_
+ _05940_ sky130_fd_sc_hd__ha_1
X_10903_ stage3_in_r\[157\] _02455_ VSS VSS VDD VDD _02456_
+ _02457_ sky130_fd_sc_hd__ha_1
X_10904_ stage3_in_r\[157\] _02458_ VSS VSS VDD VDD _02459_
+ _05941_ sky130_fd_sc_hd__ha_1
X_10905_ stage3_in_r\[158\] _02460_ VSS VSS VDD VDD _02461_
+ _02462_ sky130_fd_sc_hd__ha_1
X_10906_ stage3_in_r\[158\] _02463_ VSS VSS VDD VDD _02464_
+ _05942_ sky130_fd_sc_hd__ha_1
X_10907_ stage3_in_r\[158\] _02414_ VSS VSS VDD VDD _05943_
+ _02465_ sky130_fd_sc_hd__ha_1
X_10908_ stage3_in_r\[158\] _02466_ VSS VSS VDD VDD _02467_
+ _05944_ sky130_fd_sc_hd__ha_1
X_10909_ _01089_ stage3_in_r\[241\] VSS VSS VDD VDD _02468_
+ _02469_ sky130_fd_sc_hd__ha_1
X_10910_ stage3_in_r\[113\] stage3_in_r\[241\] VSS VSS VDD
+ VDD _02470_ _05945_ sky130_fd_sc_hd__ha_1
X_10911_ _02471_ stage3_in_r\[242\] VSS VSS VDD VDD _02472_
+ _02473_ sky130_fd_sc_hd__ha_1
X_10912_ stage3_in_r\[114\] stage3_in_r\[242\] VSS VSS VDD
+ VDD _02474_ _05946_ sky130_fd_sc_hd__ha_1
X_10913_ _02475_ stage3_in_r\[243\] VSS VSS VDD VDD _02476_
+ _02477_ sky130_fd_sc_hd__ha_1
X_10914_ stage3_in_r\[115\] stage3_in_r\[243\] VSS VSS VDD
+ VDD _02478_ _05947_ sky130_fd_sc_hd__ha_1
X_10915_ _02479_ stage3_in_r\[244\] VSS VSS VDD VDD _02480_
+ _02481_ sky130_fd_sc_hd__ha_1
X_10916_ stage3_in_r\[116\] stage3_in_r\[244\] VSS VSS VDD
+ VDD _02482_ _05948_ sky130_fd_sc_hd__ha_1
X_10917_ _02483_ stage3_in_r\[245\] VSS VSS VDD VDD _02484_
+ _02485_ sky130_fd_sc_hd__ha_1
X_10918_ stage3_in_r\[117\] stage3_in_r\[245\] VSS VSS VDD
+ VDD _02486_ _05949_ sky130_fd_sc_hd__ha_1
X_10919_ _02487_ stage3_in_r\[246\] VSS VSS VDD VDD _02488_
+ _02489_ sky130_fd_sc_hd__ha_1
X_10920_ stage3_in_r\[118\] stage3_in_r\[246\] VSS VSS VDD
+ VDD _02490_ _05950_ sky130_fd_sc_hd__ha_1
X_10921_ _02491_ stage3_in_r\[247\] VSS VSS VDD VDD _02492_
+ _02493_ sky130_fd_sc_hd__ha_1
X_10922_ stage3_in_r\[119\] stage3_in_r\[247\] VSS VSS VDD
+ VDD _02494_ _05951_ sky130_fd_sc_hd__ha_1
X_10923_ _02495_ stage3_in_r\[248\] VSS VSS VDD VDD _02496_
+ _02497_ sky130_fd_sc_hd__ha_1
X_10924_ stage3_in_r\[120\] stage3_in_r\[248\] VSS VSS VDD
+ VDD _02498_ _05952_ sky130_fd_sc_hd__ha_1
X_10925_ _02499_ stage3_in_r\[249\] VSS VSS VDD VDD _02500_
+ _02501_ sky130_fd_sc_hd__ha_1
X_10926_ stage3_in_r\[121\] stage3_in_r\[249\] VSS VSS VDD
+ VDD _02502_ _05953_ sky130_fd_sc_hd__ha_1
X_10927_ _02503_ stage3_in_r\[250\] VSS VSS VDD VDD _02504_
+ _02505_ sky130_fd_sc_hd__ha_1
X_10928_ stage3_in_r\[122\] stage3_in_r\[250\] VSS VSS VDD
+ VDD _02506_ _05954_ sky130_fd_sc_hd__ha_1
X_10929_ _02507_ stage3_in_r\[251\] VSS VSS VDD VDD _02508_
+ _02509_ sky130_fd_sc_hd__ha_1
X_10930_ stage3_in_r\[123\] stage3_in_r\[251\] VSS VSS VDD
+ VDD _02510_ _05955_ sky130_fd_sc_hd__ha_1
X_10931_ _02511_ stage3_in_r\[252\] VSS VSS VDD VDD _02512_
+ _02513_ sky130_fd_sc_hd__ha_1
X_10932_ stage3_in_r\[124\] stage3_in_r\[252\] VSS VSS VDD
+ VDD _02514_ _05956_ sky130_fd_sc_hd__ha_1
X_10933_ _02515_ stage3_in_r\[253\] VSS VSS VDD VDD _02516_
+ _02517_ sky130_fd_sc_hd__ha_1
X_10934_ stage3_in_r\[125\] stage3_in_r\[253\] VSS VSS VDD
+ VDD _02518_ _05957_ sky130_fd_sc_hd__ha_1
X_10935_ _02519_ stage3_in_r\[254\] VSS VSS VDD VDD _02520_
+ _02521_ sky130_fd_sc_hd__ha_1
X_10936_ stage3_in_r\[126\] stage3_in_r\[254\] VSS VSS VDD
+ VDD _02522_ _05958_ sky130_fd_sc_hd__ha_1
X_10937_ _02523_ stage3_in_r\[255\] VSS VSS VDD VDD _02524_
+ _02525_ sky130_fd_sc_hd__ha_1
X_10938_ stage3_in_r\[127\] stage3_in_r\[255\] VSS VSS VDD
+ VDD _02526_ _05959_ sky130_fd_sc_hd__ha_1
X_10939_ _02527_ _02528_ VSS VSS VDD VDD _02529_ stage2_out\[64\]
+ sky130_fd_sc_hd__ha_1
X_10940_ _01081_ stage2_in_r\[113\] VSS VSS VDD VDD _02530_
+ _02531_ sky130_fd_sc_hd__ha_1
X_10941_ stage2_in_r\[49\] stage2_in_r\[113\] VSS VSS VDD
+ VDD _02532_ _05960_ sky130_fd_sc_hd__ha_1
X_10942_ _02533_ stage2_in_r\[114\] VSS VSS VDD VDD _02534_
+ _02535_ sky130_fd_sc_hd__ha_1
X_10943_ stage2_in_r\[50\] stage2_in_r\[114\] VSS VSS VDD
+ VDD _02536_ _05961_ sky130_fd_sc_hd__ha_1
X_10944_ _02537_ stage2_in_r\[115\] VSS VSS VDD VDD _02538_
+ _02539_ sky130_fd_sc_hd__ha_1
X_10945_ stage2_in_r\[51\] stage2_in_r\[115\] VSS VSS VDD
+ VDD _02540_ _05962_ sky130_fd_sc_hd__ha_1
X_10946_ _02541_ stage2_in_r\[116\] VSS VSS VDD VDD _02542_
+ _02543_ sky130_fd_sc_hd__ha_1
X_10947_ stage2_in_r\[52\] stage2_in_r\[116\] VSS VSS VDD
+ VDD _02544_ _05963_ sky130_fd_sc_hd__ha_1
X_10948_ _02545_ stage2_in_r\[117\] VSS VSS VDD VDD _02546_
+ _02547_ sky130_fd_sc_hd__ha_1
X_10949_ stage2_in_r\[53\] stage2_in_r\[117\] VSS VSS VDD
+ VDD _02548_ _05964_ sky130_fd_sc_hd__ha_1
X_10950_ _02549_ stage2_in_r\[118\] VSS VSS VDD VDD _02550_
+ _02551_ sky130_fd_sc_hd__ha_1
X_10951_ stage2_in_r\[54\] stage2_in_r\[118\] VSS VSS VDD
+ VDD _02552_ _05965_ sky130_fd_sc_hd__ha_1
X_10952_ _02553_ stage2_in_r\[119\] VSS VSS VDD VDD _02554_
+ _02555_ sky130_fd_sc_hd__ha_1
X_10953_ stage2_in_r\[55\] stage2_in_r\[119\] VSS VSS VDD
+ VDD _02556_ _05966_ sky130_fd_sc_hd__ha_1
X_10954_ _02557_ stage2_in_r\[120\] VSS VSS VDD VDD _02558_
+ _02559_ sky130_fd_sc_hd__ha_1
X_10955_ stage2_in_r\[56\] stage2_in_r\[120\] VSS VSS VDD
+ VDD _02560_ _05967_ sky130_fd_sc_hd__ha_1
X_10956_ _02561_ stage2_in_r\[121\] VSS VSS VDD VDD _02562_
+ _02563_ sky130_fd_sc_hd__ha_1
X_10957_ stage2_in_r\[57\] stage2_in_r\[121\] VSS VSS VDD
+ VDD _02564_ _05968_ sky130_fd_sc_hd__ha_1
X_10958_ _02565_ stage2_in_r\[122\] VSS VSS VDD VDD _02566_
+ _02567_ sky130_fd_sc_hd__ha_1
X_10959_ stage2_in_r\[58\] stage2_in_r\[122\] VSS VSS VDD
+ VDD _02568_ _05969_ sky130_fd_sc_hd__ha_1
X_10960_ _02569_ stage2_in_r\[123\] VSS VSS VDD VDD _02570_
+ _02571_ sky130_fd_sc_hd__ha_1
X_10961_ stage2_in_r\[59\] stage2_in_r\[123\] VSS VSS VDD
+ VDD _02572_ _05970_ sky130_fd_sc_hd__ha_1
X_10962_ _02573_ stage2_in_r\[124\] VSS VSS VDD VDD _02574_
+ _02575_ sky130_fd_sc_hd__ha_1
X_10963_ stage2_in_r\[60\] stage2_in_r\[124\] VSS VSS VDD
+ VDD _02576_ _05971_ sky130_fd_sc_hd__ha_1
X_10964_ _02577_ stage2_in_r\[125\] VSS VSS VDD VDD _02578_
+ _02579_ sky130_fd_sc_hd__ha_1
X_10965_ stage2_in_r\[61\] stage2_in_r\[125\] VSS VSS VDD
+ VDD _02580_ _05972_ sky130_fd_sc_hd__ha_1
X_10966_ _02581_ stage2_in_r\[126\] VSS VSS VDD VDD _02582_
+ _02583_ sky130_fd_sc_hd__ha_1
X_10967_ stage2_in_r\[62\] stage2_in_r\[126\] VSS VSS VDD
+ VDD _02584_ _05973_ sky130_fd_sc_hd__ha_1
X_10968_ _02585_ stage2_in_r\[127\] VSS VSS VDD VDD _02586_
+ _02587_ sky130_fd_sc_hd__ha_1
X_10969_ stage2_in_r\[63\] stage2_in_r\[127\] VSS VSS VDD
+ VDD _02588_ _05974_ sky130_fd_sc_hd__ha_1
X_10970_ _02589_ _02590_ VSS VSS VDD VDD _02591_ stage2_out\[192\]
+ sky130_fd_sc_hd__ha_1
X_10971_ _01072_ stage2_in_r\[241\] VSS VSS VDD VDD _02592_
+ _02593_ sky130_fd_sc_hd__ha_1
X_10972_ stage2_in_r\[177\] stage2_in_r\[241\] VSS VSS VDD
+ VDD _02594_ _05975_ sky130_fd_sc_hd__ha_1
X_10973_ _02595_ stage2_in_r\[242\] VSS VSS VDD VDD _02596_
+ _02597_ sky130_fd_sc_hd__ha_1
X_10974_ stage2_in_r\[178\] stage2_in_r\[242\] VSS VSS VDD
+ VDD _02598_ _05976_ sky130_fd_sc_hd__ha_1
X_10975_ _02599_ stage2_in_r\[243\] VSS VSS VDD VDD _02600_
+ _02601_ sky130_fd_sc_hd__ha_1
X_10976_ stage2_in_r\[179\] stage2_in_r\[243\] VSS VSS VDD
+ VDD _02602_ _05977_ sky130_fd_sc_hd__ha_1
X_10977_ _02603_ stage2_in_r\[244\] VSS VSS VDD VDD _02604_
+ _02605_ sky130_fd_sc_hd__ha_1
X_10978_ stage2_in_r\[180\] stage2_in_r\[244\] VSS VSS VDD
+ VDD _02606_ _05978_ sky130_fd_sc_hd__ha_1
X_10979_ _02607_ stage2_in_r\[245\] VSS VSS VDD VDD _02608_
+ _02609_ sky130_fd_sc_hd__ha_1
X_10980_ stage2_in_r\[181\] stage2_in_r\[245\] VSS VSS VDD
+ VDD _02610_ _05979_ sky130_fd_sc_hd__ha_1
X_10981_ _02611_ stage2_in_r\[246\] VSS VSS VDD VDD _02612_
+ _02613_ sky130_fd_sc_hd__ha_1
X_10982_ stage2_in_r\[182\] stage2_in_r\[246\] VSS VSS VDD
+ VDD _02614_ _05980_ sky130_fd_sc_hd__ha_1
X_10983_ _02615_ stage2_in_r\[247\] VSS VSS VDD VDD _02616_
+ _02617_ sky130_fd_sc_hd__ha_1
X_10984_ stage2_in_r\[183\] stage2_in_r\[247\] VSS VSS VDD
+ VDD _02618_ _05981_ sky130_fd_sc_hd__ha_1
X_10985_ _02619_ stage2_in_r\[248\] VSS VSS VDD VDD _02620_
+ _02621_ sky130_fd_sc_hd__ha_1
X_10986_ stage2_in_r\[184\] stage2_in_r\[248\] VSS VSS VDD
+ VDD _02622_ _05982_ sky130_fd_sc_hd__ha_1
X_10987_ _02623_ stage2_in_r\[249\] VSS VSS VDD VDD _02624_
+ _02625_ sky130_fd_sc_hd__ha_1
X_10988_ stage2_in_r\[185\] stage2_in_r\[249\] VSS VSS VDD
+ VDD _02626_ _05983_ sky130_fd_sc_hd__ha_1
X_10989_ _02627_ stage2_in_r\[250\] VSS VSS VDD VDD _02628_
+ _02629_ sky130_fd_sc_hd__ha_1
X_10990_ stage2_in_r\[186\] stage2_in_r\[250\] VSS VSS VDD
+ VDD _02630_ _05984_ sky130_fd_sc_hd__ha_1
X_10991_ _02631_ stage2_in_r\[251\] VSS VSS VDD VDD _02632_
+ _02633_ sky130_fd_sc_hd__ha_1
X_10992_ stage2_in_r\[187\] stage2_in_r\[251\] VSS VSS VDD
+ VDD _02634_ _05985_ sky130_fd_sc_hd__ha_1
X_10993_ _02635_ stage2_in_r\[252\] VSS VSS VDD VDD _02636_
+ _02637_ sky130_fd_sc_hd__ha_1
X_10994_ stage2_in_r\[188\] stage2_in_r\[252\] VSS VSS VDD
+ VDD _02638_ _05986_ sky130_fd_sc_hd__ha_1
X_10995_ _02639_ stage2_in_r\[253\] VSS VSS VDD VDD _02640_
+ _02641_ sky130_fd_sc_hd__ha_1
X_10996_ stage2_in_r\[189\] stage2_in_r\[253\] VSS VSS VDD
+ VDD _02642_ _05987_ sky130_fd_sc_hd__ha_1
X_10997_ _02643_ stage2_in_r\[254\] VSS VSS VDD VDD _02644_
+ _02645_ sky130_fd_sc_hd__ha_1
X_10998_ stage2_in_r\[190\] stage2_in_r\[254\] VSS VSS VDD
+ VDD _02646_ _05988_ sky130_fd_sc_hd__ha_1
X_10999_ _02647_ stage2_in_r\[255\] VSS VSS VDD VDD _02648_
+ _02649_ sky130_fd_sc_hd__ha_1
X_11000_ stage2_in_r\[191\] stage2_in_r\[255\] VSS VSS VDD
+ VDD _02650_ _05989_ sky130_fd_sc_hd__ha_1
X_11001_ _01068_ stage1_in_r\[49\] VSS VSS VDD VDD _02651_
+ _02652_ sky130_fd_sc_hd__ha_1
X_11002_ stage1_in_r\[17\] stage1_in_r\[49\] VSS VSS VDD VDD
+ _02653_ _05990_ sky130_fd_sc_hd__ha_1
X_11003_ _02654_ stage1_in_r\[50\] VSS VSS VDD VDD _02655_
+ _02656_ sky130_fd_sc_hd__ha_1
X_11004_ stage1_in_r\[18\] stage1_in_r\[50\] VSS VSS VDD VDD
+ _02657_ _05991_ sky130_fd_sc_hd__ha_1
X_11005_ _02658_ stage1_in_r\[51\] VSS VSS VDD VDD _02659_
+ _02660_ sky130_fd_sc_hd__ha_1
X_11006_ stage1_in_r\[19\] stage1_in_r\[51\] VSS VSS VDD VDD
+ _02661_ _05992_ sky130_fd_sc_hd__ha_1
X_11007_ _02662_ stage1_in_r\[52\] VSS VSS VDD VDD _02663_
+ _02664_ sky130_fd_sc_hd__ha_1
X_11008_ stage1_in_r\[20\] stage1_in_r\[52\] VSS VSS VDD VDD
+ _02665_ _05993_ sky130_fd_sc_hd__ha_1
X_11009_ _02666_ stage1_in_r\[53\] VSS VSS VDD VDD _02667_
+ _02668_ sky130_fd_sc_hd__ha_1
X_11010_ stage1_in_r\[21\] stage1_in_r\[53\] VSS VSS VDD VDD
+ _02669_ _05994_ sky130_fd_sc_hd__ha_1
X_11011_ _02670_ stage1_in_r\[54\] VSS VSS VDD VDD _02671_
+ _02672_ sky130_fd_sc_hd__ha_1
X_11012_ stage1_in_r\[22\] stage1_in_r\[54\] VSS VSS VDD VDD
+ _02673_ _05995_ sky130_fd_sc_hd__ha_1
X_11013_ _02674_ stage1_in_r\[55\] VSS VSS VDD VDD _02675_
+ _02676_ sky130_fd_sc_hd__ha_1
X_11014_ stage1_in_r\[23\] stage1_in_r\[55\] VSS VSS VDD VDD
+ _02677_ _05996_ sky130_fd_sc_hd__ha_1
X_11015_ _02678_ stage1_in_r\[56\] VSS VSS VDD VDD _02679_
+ _02680_ sky130_fd_sc_hd__ha_1
X_11016_ stage1_in_r\[24\] stage1_in_r\[56\] VSS VSS VDD VDD
+ _02681_ _05997_ sky130_fd_sc_hd__ha_1
X_11017_ _02682_ stage1_in_r\[57\] VSS VSS VDD VDD _02683_
+ _02684_ sky130_fd_sc_hd__ha_1
X_11018_ stage1_in_r\[25\] stage1_in_r\[57\] VSS VSS VDD VDD
+ _02685_ _05998_ sky130_fd_sc_hd__ha_1
X_11019_ _02686_ stage1_in_r\[58\] VSS VSS VDD VDD _02687_
+ _02688_ sky130_fd_sc_hd__ha_1
X_11020_ stage1_in_r\[26\] stage1_in_r\[58\] VSS VSS VDD VDD
+ _02689_ _05999_ sky130_fd_sc_hd__ha_1
X_11021_ _02690_ stage1_in_r\[59\] VSS VSS VDD VDD _02691_
+ _02692_ sky130_fd_sc_hd__ha_1
X_11022_ stage1_in_r\[27\] stage1_in_r\[59\] VSS VSS VDD VDD
+ _02693_ _06000_ sky130_fd_sc_hd__ha_1
X_11023_ _02694_ stage1_in_r\[60\] VSS VSS VDD VDD _02695_
+ _02696_ sky130_fd_sc_hd__ha_1
X_11024_ stage1_in_r\[28\] stage1_in_r\[60\] VSS VSS VDD VDD
+ _02697_ _06001_ sky130_fd_sc_hd__ha_1
X_11025_ _02698_ stage1_in_r\[61\] VSS VSS VDD VDD _02699_
+ _02700_ sky130_fd_sc_hd__ha_1
X_11026_ stage1_in_r\[29\] stage1_in_r\[61\] VSS VSS VDD VDD
+ _02701_ _06002_ sky130_fd_sc_hd__ha_1
X_11027_ _02702_ stage1_in_r\[62\] VSS VSS VDD VDD _02703_
+ _02704_ sky130_fd_sc_hd__ha_1
X_11028_ stage1_in_r\[30\] stage1_in_r\[62\] VSS VSS VDD VDD
+ _02705_ _06003_ sky130_fd_sc_hd__ha_1
X_11029_ _02706_ stage1_in_r\[63\] VSS VSS VDD VDD _02707_
+ _02708_ sky130_fd_sc_hd__ha_1
X_11030_ stage1_in_r\[31\] stage1_in_r\[63\] VSS VSS VDD VDD
+ _02709_ _06004_ sky130_fd_sc_hd__ha_1
X_11031_ _01059_ stage1_in_r\[113\] VSS VSS VDD VDD _02710_
+ _02711_ sky130_fd_sc_hd__ha_1
X_11032_ stage1_in_r\[81\] stage1_in_r\[113\] VSS VSS VDD
+ VDD _02712_ _06005_ sky130_fd_sc_hd__ha_1
X_11033_ _02713_ stage1_in_r\[114\] VSS VSS VDD VDD _02714_
+ _02715_ sky130_fd_sc_hd__ha_1
X_11034_ stage1_in_r\[82\] stage1_in_r\[114\] VSS VSS VDD
+ VDD _02716_ _06006_ sky130_fd_sc_hd__ha_1
X_11035_ _02717_ stage1_in_r\[115\] VSS VSS VDD VDD _02718_
+ _02719_ sky130_fd_sc_hd__ha_1
X_11036_ stage1_in_r\[83\] stage1_in_r\[115\] VSS VSS VDD
+ VDD _02720_ _06007_ sky130_fd_sc_hd__ha_1
X_11037_ _02721_ stage1_in_r\[116\] VSS VSS VDD VDD _02722_
+ _02723_ sky130_fd_sc_hd__ha_1
X_11038_ stage1_in_r\[84\] stage1_in_r\[116\] VSS VSS VDD
+ VDD _02724_ _06008_ sky130_fd_sc_hd__ha_1
X_11039_ _02725_ stage1_in_r\[117\] VSS VSS VDD VDD _02726_
+ _02727_ sky130_fd_sc_hd__ha_1
X_11040_ stage1_in_r\[85\] stage1_in_r\[117\] VSS VSS VDD
+ VDD _02728_ _06009_ sky130_fd_sc_hd__ha_1
X_11041_ _02729_ stage1_in_r\[118\] VSS VSS VDD VDD _02730_
+ _02731_ sky130_fd_sc_hd__ha_1
X_11042_ stage1_in_r\[86\] stage1_in_r\[118\] VSS VSS VDD
+ VDD _02732_ _06010_ sky130_fd_sc_hd__ha_1
X_11043_ _02733_ stage1_in_r\[119\] VSS VSS VDD VDD _02734_
+ _02735_ sky130_fd_sc_hd__ha_1
X_11044_ stage1_in_r\[87\] stage1_in_r\[119\] VSS VSS VDD
+ VDD _02736_ _06011_ sky130_fd_sc_hd__ha_1
X_11045_ _02737_ stage1_in_r\[120\] VSS VSS VDD VDD _02738_
+ _02739_ sky130_fd_sc_hd__ha_1
X_11046_ stage1_in_r\[88\] stage1_in_r\[120\] VSS VSS VDD
+ VDD _02740_ _06012_ sky130_fd_sc_hd__ha_1
X_11047_ _02741_ stage1_in_r\[121\] VSS VSS VDD VDD _02742_
+ _02743_ sky130_fd_sc_hd__ha_1
X_11048_ stage1_in_r\[89\] stage1_in_r\[121\] VSS VSS VDD
+ VDD _02744_ _06013_ sky130_fd_sc_hd__ha_1
X_11049_ _02745_ stage1_in_r\[122\] VSS VSS VDD VDD _02746_
+ _02747_ sky130_fd_sc_hd__ha_1
X_11050_ stage1_in_r\[90\] stage1_in_r\[122\] VSS VSS VDD
+ VDD _02748_ _06014_ sky130_fd_sc_hd__ha_1
X_11051_ _02749_ stage1_in_r\[123\] VSS VSS VDD VDD _02750_
+ _02751_ sky130_fd_sc_hd__ha_1
X_11052_ stage1_in_r\[91\] stage1_in_r\[123\] VSS VSS VDD
+ VDD _02752_ _06015_ sky130_fd_sc_hd__ha_1
X_11053_ _02753_ stage1_in_r\[124\] VSS VSS VDD VDD _02754_
+ _02755_ sky130_fd_sc_hd__ha_1
X_11054_ stage1_in_r\[92\] stage1_in_r\[124\] VSS VSS VDD
+ VDD _02756_ _06016_ sky130_fd_sc_hd__ha_1
X_11055_ _02757_ stage1_in_r\[125\] VSS VSS VDD VDD _02758_
+ _02759_ sky130_fd_sc_hd__ha_1
X_11056_ stage1_in_r\[93\] stage1_in_r\[125\] VSS VSS VDD
+ VDD _02760_ _06017_ sky130_fd_sc_hd__ha_1
X_11057_ _02761_ stage1_in_r\[126\] VSS VSS VDD VDD _02762_
+ _02763_ sky130_fd_sc_hd__ha_1
X_11058_ stage1_in_r\[94\] stage1_in_r\[126\] VSS VSS VDD
+ VDD _02764_ _06018_ sky130_fd_sc_hd__ha_1
X_11059_ _02765_ stage1_in_r\[127\] VSS VSS VDD VDD _02766_
+ _02767_ sky130_fd_sc_hd__ha_1
X_11060_ stage1_in_r\[95\] stage1_in_r\[127\] VSS VSS VDD
+ VDD _02768_ _06019_ sky130_fd_sc_hd__ha_1
X_11061_ _01055_ stage1_in_r\[177\] VSS VSS VDD VDD _02769_
+ _02770_ sky130_fd_sc_hd__ha_1
X_11062_ stage1_in_r\[145\] stage1_in_r\[177\] VSS VSS VDD
+ VDD _02771_ _06020_ sky130_fd_sc_hd__ha_1
X_11063_ _02772_ stage1_in_r\[178\] VSS VSS VDD VDD _02773_
+ _02774_ sky130_fd_sc_hd__ha_1
X_11064_ stage1_in_r\[146\] stage1_in_r\[178\] VSS VSS VDD
+ VDD _02775_ _06021_ sky130_fd_sc_hd__ha_1
X_11065_ _02776_ stage1_in_r\[179\] VSS VSS VDD VDD _02777_
+ _02778_ sky130_fd_sc_hd__ha_1
X_11066_ stage1_in_r\[147\] stage1_in_r\[179\] VSS VSS VDD
+ VDD _02779_ _06022_ sky130_fd_sc_hd__ha_1
X_11067_ _02780_ stage1_in_r\[180\] VSS VSS VDD VDD _02781_
+ _02782_ sky130_fd_sc_hd__ha_1
X_11068_ stage1_in_r\[148\] stage1_in_r\[180\] VSS VSS VDD
+ VDD _02783_ _06023_ sky130_fd_sc_hd__ha_1
X_11069_ _02784_ stage1_in_r\[181\] VSS VSS VDD VDD _02785_
+ _02786_ sky130_fd_sc_hd__ha_1
X_11070_ stage1_in_r\[149\] stage1_in_r\[181\] VSS VSS VDD
+ VDD _02787_ _06024_ sky130_fd_sc_hd__ha_1
X_11071_ _02788_ stage1_in_r\[182\] VSS VSS VDD VDD _02789_
+ _02790_ sky130_fd_sc_hd__ha_1
X_11072_ stage1_in_r\[150\] stage1_in_r\[182\] VSS VSS VDD
+ VDD _02791_ _06025_ sky130_fd_sc_hd__ha_1
X_11073_ _02792_ stage1_in_r\[183\] VSS VSS VDD VDD _02793_
+ _02794_ sky130_fd_sc_hd__ha_1
X_11074_ stage1_in_r\[151\] stage1_in_r\[183\] VSS VSS VDD
+ VDD _02795_ _06026_ sky130_fd_sc_hd__ha_1
X_11075_ _02796_ stage1_in_r\[184\] VSS VSS VDD VDD _02797_
+ _02798_ sky130_fd_sc_hd__ha_1
X_11076_ stage1_in_r\[152\] stage1_in_r\[184\] VSS VSS VDD
+ VDD _02799_ _06027_ sky130_fd_sc_hd__ha_1
X_11077_ _02800_ stage1_in_r\[185\] VSS VSS VDD VDD _02801_
+ _02802_ sky130_fd_sc_hd__ha_1
X_11078_ stage1_in_r\[153\] stage1_in_r\[185\] VSS VSS VDD
+ VDD _02803_ _06028_ sky130_fd_sc_hd__ha_1
X_11079_ _02804_ stage1_in_r\[186\] VSS VSS VDD VDD _02805_
+ _02806_ sky130_fd_sc_hd__ha_1
X_11080_ stage1_in_r\[154\] stage1_in_r\[186\] VSS VSS VDD
+ VDD _02807_ _06029_ sky130_fd_sc_hd__ha_1
X_11081_ _02808_ stage1_in_r\[187\] VSS VSS VDD VDD _02809_
+ _02810_ sky130_fd_sc_hd__ha_1
X_11082_ stage1_in_r\[155\] stage1_in_r\[187\] VSS VSS VDD
+ VDD _02811_ _06030_ sky130_fd_sc_hd__ha_1
X_11083_ _02812_ stage1_in_r\[188\] VSS VSS VDD VDD _02813_
+ _02814_ sky130_fd_sc_hd__ha_1
X_11084_ stage1_in_r\[156\] stage1_in_r\[188\] VSS VSS VDD
+ VDD _02815_ _06031_ sky130_fd_sc_hd__ha_1
X_11085_ _02816_ stage1_in_r\[189\] VSS VSS VDD VDD _02817_
+ _02818_ sky130_fd_sc_hd__ha_1
X_11086_ stage1_in_r\[157\] stage1_in_r\[189\] VSS VSS VDD
+ VDD _02819_ _06032_ sky130_fd_sc_hd__ha_1
X_11087_ _02820_ stage1_in_r\[190\] VSS VSS VDD VDD _02821_
+ _02822_ sky130_fd_sc_hd__ha_1
X_11088_ stage1_in_r\[158\] stage1_in_r\[190\] VSS VSS VDD
+ VDD _02823_ _06033_ sky130_fd_sc_hd__ha_1
X_11089_ _02824_ stage1_in_r\[191\] VSS VSS VDD VDD _02825_
+ _02826_ sky130_fd_sc_hd__ha_1
X_11090_ stage1_in_r\[159\] stage1_in_r\[191\] VSS VSS VDD
+ VDD _02827_ _06034_ sky130_fd_sc_hd__ha_1
X_11091_ _01046_ stage1_in_r\[241\] VSS VSS VDD VDD _02828_
+ _02829_ sky130_fd_sc_hd__ha_1
X_11092_ stage1_in_r\[209\] stage1_in_r\[241\] VSS VSS VDD
+ VDD _02830_ _06035_ sky130_fd_sc_hd__ha_1
X_11093_ _02831_ stage1_in_r\[242\] VSS VSS VDD VDD _02832_
+ _02833_ sky130_fd_sc_hd__ha_1
X_11094_ stage1_in_r\[210\] stage1_in_r\[242\] VSS VSS VDD
+ VDD _02834_ _06036_ sky130_fd_sc_hd__ha_1
X_11095_ _02835_ stage1_in_r\[243\] VSS VSS VDD VDD _02836_
+ _02837_ sky130_fd_sc_hd__ha_1
X_11096_ stage1_in_r\[211\] stage1_in_r\[243\] VSS VSS VDD
+ VDD _02838_ _06037_ sky130_fd_sc_hd__ha_1
X_11097_ _02839_ stage1_in_r\[244\] VSS VSS VDD VDD _02840_
+ _02841_ sky130_fd_sc_hd__ha_1
X_11098_ stage1_in_r\[212\] stage1_in_r\[244\] VSS VSS VDD
+ VDD _02842_ _06038_ sky130_fd_sc_hd__ha_1
X_11099_ _02843_ stage1_in_r\[245\] VSS VSS VDD VDD _02844_
+ _02845_ sky130_fd_sc_hd__ha_1
X_11100_ stage1_in_r\[213\] stage1_in_r\[245\] VSS VSS VDD
+ VDD _02846_ _06039_ sky130_fd_sc_hd__ha_1
X_11101_ _02847_ stage1_in_r\[246\] VSS VSS VDD VDD _02848_
+ _02849_ sky130_fd_sc_hd__ha_1
X_11102_ stage1_in_r\[214\] stage1_in_r\[246\] VSS VSS VDD
+ VDD _02850_ _06040_ sky130_fd_sc_hd__ha_1
X_11103_ _02851_ stage1_in_r\[247\] VSS VSS VDD VDD _02852_
+ _02853_ sky130_fd_sc_hd__ha_1
X_11104_ stage1_in_r\[215\] stage1_in_r\[247\] VSS VSS VDD
+ VDD _02854_ _06041_ sky130_fd_sc_hd__ha_1
X_11105_ _02855_ stage1_in_r\[248\] VSS VSS VDD VDD _02856_
+ _02857_ sky130_fd_sc_hd__ha_1
X_11106_ stage1_in_r\[216\] stage1_in_r\[248\] VSS VSS VDD
+ VDD _02858_ _06042_ sky130_fd_sc_hd__ha_1
X_11107_ _02859_ stage1_in_r\[249\] VSS VSS VDD VDD _02860_
+ _02861_ sky130_fd_sc_hd__ha_1
X_11108_ stage1_in_r\[217\] stage1_in_r\[249\] VSS VSS VDD
+ VDD _02862_ _06043_ sky130_fd_sc_hd__ha_1
X_11109_ _02863_ stage1_in_r\[250\] VSS VSS VDD VDD _02864_
+ _02865_ sky130_fd_sc_hd__ha_1
X_11110_ stage1_in_r\[218\] stage1_in_r\[250\] VSS VSS VDD
+ VDD _02866_ _06044_ sky130_fd_sc_hd__ha_1
X_11111_ _02867_ stage1_in_r\[251\] VSS VSS VDD VDD _02868_
+ _02869_ sky130_fd_sc_hd__ha_1
X_11112_ stage1_in_r\[219\] stage1_in_r\[251\] VSS VSS VDD
+ VDD _02870_ _06045_ sky130_fd_sc_hd__ha_1
X_11113_ _02871_ stage1_in_r\[252\] VSS VSS VDD VDD _02872_
+ _02873_ sky130_fd_sc_hd__ha_1
X_11114_ stage1_in_r\[220\] stage1_in_r\[252\] VSS VSS VDD
+ VDD _02874_ _06046_ sky130_fd_sc_hd__ha_1
X_11115_ _02875_ stage1_in_r\[253\] VSS VSS VDD VDD _02876_
+ _02877_ sky130_fd_sc_hd__ha_1
X_11116_ stage1_in_r\[221\] stage1_in_r\[253\] VSS VSS VDD
+ VDD _02878_ _06047_ sky130_fd_sc_hd__ha_1
X_11117_ _02879_ stage1_in_r\[254\] VSS VSS VDD VDD _02880_
+ _02881_ sky130_fd_sc_hd__ha_1
X_11118_ stage1_in_r\[222\] stage1_in_r\[254\] VSS VSS VDD
+ VDD _02882_ _06048_ sky130_fd_sc_hd__ha_1
X_11119_ _02883_ stage1_in_r\[255\] VSS VSS VDD VDD _02884_
+ _02885_ sky130_fd_sc_hd__ha_1
X_11120_ stage1_in_r\[223\] stage1_in_r\[255\] VSS VSS VDD
+ VDD _02886_ _06049_ sky130_fd_sc_hd__ha_1
XTAP_TAPCELL_ROW_0_0 VSS VDD sky130_fd_sc_hd__tapvpwrvgnd_1
Xinput82 in_flat[29] VSS VSS VDD VDD net81 sky130_fd_sc_hd__clkdlybuf4s50_1
Xinput81 in_flat[28] VSS VSS VDD VDD net80 sky130_fd_sc_hd__clkdlybuf4s50_1
Xinput80 in_flat[27] VSS VSS VDD VDD net79 sky130_fd_sc_hd__clkdlybuf4s50_1
Xinput79 in_flat[26] VSS VSS VDD VDD net78 sky130_fd_sc_hd__clkdlybuf4s50_1
Xinput78 in_flat[25] VSS VSS VDD VDD net77 sky130_fd_sc_hd__clkdlybuf4s50_1
Xinput77 in_flat[24] VSS VSS VDD VDD net76 sky130_fd_sc_hd__clkdlybuf4s50_1
Xinput76 in_flat[23] VSS VSS VDD VDD net75 sky130_fd_sc_hd__clkdlybuf4s50_1
Xinput75 in_flat[22] VSS VSS VDD VDD net74 sky130_fd_sc_hd__clkdlybuf4s50_1
Xinput74 in_flat[21] VSS VSS VDD VDD net73 sky130_fd_sc_hd__clkdlybuf4s50_1
Xinput73 in_flat[20] VSS VSS VDD VDD net72 sky130_fd_sc_hd__clkdlybuf4s50_1
Xinput72 in_flat[1] VSS VSS VDD VDD net71 sky130_fd_sc_hd__clkdlybuf4s50_1
Xinput71 in_flat[19] VSS VSS VDD VDD net70 sky130_fd_sc_hd__clkdlybuf4s50_1
Xinput70 in_flat[18] VSS VSS VDD VDD net69 sky130_fd_sc_hd__clkdlybuf4s50_1
Xinput69 in_flat[17] VSS VSS VDD VDD net68 sky130_fd_sc_hd__clkdlybuf4s50_1
Xinput68 in_flat[16] VSS VSS VDD VDD net67 sky130_fd_sc_hd__clkdlybuf4s50_1
Xinput67 in_flat[15] VSS VSS VDD VDD net66 sky130_fd_sc_hd__clkdlybuf4s50_1
Xinput66 in_flat[14] VSS VSS VDD VDD net65 sky130_fd_sc_hd__clkdlybuf4s50_1
Xinput65 in_flat[13] VSS VSS VDD VDD net64 sky130_fd_sc_hd__clkdlybuf4s50_1
Xinput64 in_flat[12] VSS VSS VDD VDD net63 sky130_fd_sc_hd__clkdlybuf4s50_1
Xinput63 in_flat[127] VSS VSS VDD VDD net62 sky130_fd_sc_hd__clkdlybuf4s50_1
Xinput62 in_flat[126] VSS VSS VDD VDD net61 sky130_fd_sc_hd__clkdlybuf4s50_1
Xinput61 in_flat[125] VSS VSS VDD VDD net60 sky130_fd_sc_hd__clkdlybuf4s50_1
Xinput60 in_flat[124] VSS VSS VDD VDD net59 sky130_fd_sc_hd__clkdlybuf4s50_1
Xinput59 in_flat[123] VSS VSS VDD VDD net58 sky130_fd_sc_hd__clkdlybuf4s50_1
Xinput58 in_flat[122] VSS VSS VDD VDD net57 sky130_fd_sc_hd__clkdlybuf4s50_1
Xinput57 in_flat[121] VSS VSS VDD VDD net56 sky130_fd_sc_hd__clkdlybuf4s50_1
Xinput56 in_flat[120] VSS VSS VDD VDD net55 sky130_fd_sc_hd__clkdlybuf4s50_1
Xinput55 in_flat[11] VSS VSS VDD VDD net54 sky130_fd_sc_hd__clkdlybuf4s50_1
Xinput54 in_flat[119] VSS VSS VDD VDD net53 sky130_fd_sc_hd__clkdlybuf4s50_1
Xinput53 in_flat[118] VSS VSS VDD VDD net52 sky130_fd_sc_hd__clkdlybuf4s50_1
Xinput52 in_flat[117] VSS VSS VDD VDD net51 sky130_fd_sc_hd__clkdlybuf4s50_1
Xinput51 in_flat[116] VSS VSS VDD VDD net50 sky130_fd_sc_hd__clkdlybuf4s50_1
Xinput50 in_flat[115] VSS VSS VDD VDD net49 sky130_fd_sc_hd__clkdlybuf4s50_1
Xinput49 in_flat[114] VSS VSS VDD VDD net48 sky130_fd_sc_hd__clkdlybuf4s50_1
Xinput48 in_flat[113] VSS VSS VDD VDD net47 sky130_fd_sc_hd__clkdlybuf4s50_1
Xinput47 in_flat[112] VSS VSS VDD VDD net46 sky130_fd_sc_hd__clkdlybuf4s50_1
Xinput46 in_flat[111] VSS VSS VDD VDD net45 sky130_fd_sc_hd__clkdlybuf4s50_1
Xinput45 in_flat[110] VSS VSS VDD VDD net44 sky130_fd_sc_hd__clkdlybuf4s50_1
Xinput44 in_flat[10] VSS VSS VDD VDD net43 sky130_fd_sc_hd__clkdlybuf4s50_1
Xinput43 in_flat[109] VSS VSS VDD VDD net42 sky130_fd_sc_hd__clkdlybuf4s50_1
Xinput42 in_flat[108] VSS VSS VDD VDD net41 sky130_fd_sc_hd__clkdlybuf4s50_1
Xinput41 in_flat[107] VSS VSS VDD VDD net40 sky130_fd_sc_hd__clkdlybuf4s50_1
Xinput40 in_flat[106] VSS VSS VDD VDD net39 sky130_fd_sc_hd__clkdlybuf4s50_1
Xinput39 in_flat[105] VSS VSS VDD VDD net38 sky130_fd_sc_hd__clkdlybuf4s50_1
Xinput38 in_flat[104] VSS VSS VDD VDD net37 sky130_fd_sc_hd__clkdlybuf4s50_1
Xinput37 in_flat[103] VSS VSS VDD VDD net36 sky130_fd_sc_hd__clkdlybuf4s50_1
Xinput36 in_flat[102] VSS VSS VDD VDD net35 sky130_fd_sc_hd__clkdlybuf4s50_1
Xinput35 in_flat[101] VSS VSS VDD VDD net34 sky130_fd_sc_hd__clkdlybuf4s50_1
Xinput34 in_flat[100] VSS VSS VDD VDD net33 sky130_fd_sc_hd__clkdlybuf4s50_1
Xinput33 in_flat[0] VSS VSS VDD VDD net32 sky130_fd_sc_hd__clkdlybuf4s50_1
Xout_flat\[0\]$_DFF_PN0_ clknet_leaf_48_clk stage3_out\[0\]
+ net466 VSS VSS VDD VDD net162 sky130_fd_sc_hd__dfrtp_1
Xout_flat\[10\]$_DFF_PN0_ clknet_leaf_43_clk stage3_out\[10\]
+ net466 VSS VSS VDD VDD net163 sky130_fd_sc_hd__dfrtp_1
Xout_flat\[112\]$_DFF_PN0_ clknet_leaf_3_clk stage3_out\[112\]
+ net465 VSS VSS VDD VDD net164 sky130_fd_sc_hd__dfrtp_1
Xout_flat\[113\]$_DFF_PN0_ clknet_leaf_3_clk stage3_out\[113\]
+ net465 VSS VSS VDD VDD net165 sky130_fd_sc_hd__dfrtp_1
Xout_flat\[114\]$_DFF_PN0_ clknet_leaf_3_clk stage3_out\[114\]
+ net465 VSS VSS VDD VDD net166 sky130_fd_sc_hd__dfrtp_1
Xout_flat\[115\]$_DFF_PN0_ clknet_leaf_4_clk stage3_out\[115\]
+ net465 VSS VSS VDD VDD net167 sky130_fd_sc_hd__dfrtp_1
Xout_flat\[116\]$_DFF_PN0_ clknet_leaf_4_clk stage3_out\[116\]
+ net460 VSS VSS VDD VDD net168 sky130_fd_sc_hd__dfrtp_1
Xout_flat\[117\]$_DFF_PN0_ clknet_leaf_4_clk stage3_out\[117\]
+ net460 VSS VSS VDD VDD net169 sky130_fd_sc_hd__dfrtp_1
Xout_flat\[118\]$_DFF_PN0_ clknet_leaf_7_clk stage3_out\[118\]
+ net463 VSS VSS VDD VDD net170 sky130_fd_sc_hd__dfrtp_1
Xout_flat\[119\]$_DFF_PN0_ clknet_leaf_6_clk stage3_out\[119\]
+ net461 VSS VSS VDD VDD net171 sky130_fd_sc_hd__dfrtp_1
Xout_flat\[11\]$_DFF_PN0_ clknet_leaf_42_clk stage3_out\[11\]
+ net161 VSS VSS VDD VDD net172 sky130_fd_sc_hd__dfrtp_1
Xout_flat\[120\]$_DFF_PN0_ clknet_leaf_14_clk stage3_out\[120\]
+ net460 VSS VSS VDD VDD net173 sky130_fd_sc_hd__dfrtp_1
Xout_flat\[121\]$_DFF_PN0_ clknet_leaf_15_clk stage3_out\[121\]
+ net460 VSS VSS VDD VDD net174 sky130_fd_sc_hd__dfrtp_1
Xout_flat\[122\]$_DFF_PN0_ clknet_leaf_23_clk stage3_out\[122\]
+ net467 VSS VSS VDD VDD net175 sky130_fd_sc_hd__dfrtp_1
Xout_flat\[123\]$_DFF_PN0_ clknet_leaf_26_clk stage3_out\[123\]
+ net462 VSS VSS VDD VDD net176 sky130_fd_sc_hd__dfrtp_1
Xout_flat\[124\]$_DFF_PN0_ clknet_leaf_26_clk stage3_out\[124\]
+ net467 VSS VSS VDD VDD net177 sky130_fd_sc_hd__dfrtp_1
Xout_flat\[125\]$_DFF_PN0_ clknet_leaf_27_clk stage3_out\[125\]
+ net467 VSS VSS VDD VDD net178 sky130_fd_sc_hd__dfrtp_1
Xout_flat\[126\]$_DFF_PN0_ clknet_leaf_26_clk stage3_out\[126\]
+ net467 VSS VSS VDD VDD net179 sky130_fd_sc_hd__dfrtp_1
Xout_flat\[127\]$_DFF_PN0_ clknet_leaf_27_clk stage3_out\[127\]
+ net467 VSS VSS VDD VDD net180 sky130_fd_sc_hd__dfrtp_1
Xout_flat\[128\]$_DFF_PN0_ clknet_leaf_48_clk stage3_out\[128\]
+ net466 VSS VSS VDD VDD net181 sky130_fd_sc_hd__dfrtp_1
Xout_flat\[129\]$_DFF_PN0_ clknet_leaf_51_clk stage3_out\[129\]
+ net466 VSS VSS VDD VDD net182 sky130_fd_sc_hd__dfrtp_1
Xout_flat\[12\]$_DFF_PN0_ clknet_leaf_42_clk stage3_out\[12\]
+ net161 VSS VSS VDD VDD net183 sky130_fd_sc_hd__dfrtp_1
Xout_flat\[130\]$_DFF_PN0_ clknet_leaf_47_clk stage3_out\[130\]
+ net466 VSS VSS VDD VDD net184 sky130_fd_sc_hd__dfrtp_1
Xout_flat\[131\]$_DFF_PN0_ clknet_leaf_47_clk stage3_out\[131\]
+ net466 VSS VSS VDD VDD net185 sky130_fd_sc_hd__dfrtp_1
Xout_flat\[132\]$_DFF_PN0_ clknet_leaf_47_clk stage3_out\[132\]
+ net466 VSS VSS VDD VDD net186 sky130_fd_sc_hd__dfrtp_1
Xout_flat\[133\]$_DFF_PN0_ clknet_leaf_46_clk stage3_out\[133\]
+ net466 VSS VSS VDD VDD net187 sky130_fd_sc_hd__dfrtp_1
Xout_flat\[134\]$_DFF_PN0_ clknet_leaf_46_clk stage3_out\[134\]
+ net466 VSS VSS VDD VDD net188 sky130_fd_sc_hd__dfrtp_1
Xout_flat\[135\]$_DFF_PN0_ clknet_leaf_44_clk stage3_out\[135\]
+ net466 VSS VSS VDD VDD net189 sky130_fd_sc_hd__dfrtp_1
Xout_flat\[136\]$_DFF_PN0_ clknet_leaf_44_clk stage3_out\[136\]
+ net466 VSS VSS VDD VDD net190 sky130_fd_sc_hd__dfrtp_1
Xout_flat\[137\]$_DFF_PN0_ clknet_leaf_43_clk stage3_out\[137\]
+ net466 VSS VSS VDD VDD net191 sky130_fd_sc_hd__dfrtp_1
Xout_flat\[138\]$_DFF_PN0_ clknet_leaf_43_clk stage3_out\[138\]
+ net466 VSS VSS VDD VDD net192 sky130_fd_sc_hd__dfrtp_1
Xout_flat\[139\]$_DFF_PN0_ clknet_leaf_43_clk stage3_out\[139\]
+ net161 VSS VSS VDD VDD net193 sky130_fd_sc_hd__dfrtp_1
Xout_flat\[13\]$_DFF_PN0_ clknet_leaf_42_clk stage3_out\[13\]
+ net161 VSS VSS VDD VDD net194 sky130_fd_sc_hd__dfrtp_1
Xout_flat\[140\]$_DFF_PN0_ clknet_leaf_42_clk stage3_out\[140\]
+ net161 VSS VSS VDD VDD net195 sky130_fd_sc_hd__dfrtp_1
Xout_flat\[141\]$_DFF_PN0_ clknet_leaf_42_clk stage3_out\[141\]
+ net161 VSS VSS VDD VDD net196 sky130_fd_sc_hd__dfrtp_1
Xout_flat\[142\]$_DFF_PN0_ clknet_leaf_42_clk stage3_out\[142\]
+ net161 VSS VSS VDD VDD net197 sky130_fd_sc_hd__dfrtp_1
Xout_flat\[143\]$_DFF_PN0_ clknet_leaf_42_clk stage3_out\[143\]
+ net161 VSS VSS VDD VDD net198 sky130_fd_sc_hd__dfrtp_1
Xout_flat\[144\]$_DFF_PN0_ clknet_leaf_40_clk stage3_out\[144\]
+ net161 VSS VSS VDD VDD net199 sky130_fd_sc_hd__dfrtp_1
Xout_flat\[145\]$_DFF_PN0_ clknet_leaf_43_clk stage3_out\[145\]
+ net466 VSS VSS VDD VDD net200 sky130_fd_sc_hd__dfrtp_1
Xout_flat\[146\]$_DFF_PN0_ clknet_leaf_40_clk stage3_out\[146\]
+ net161 VSS VSS VDD VDD net201 sky130_fd_sc_hd__dfrtp_1
Xout_flat\[147\]$_DFF_PN0_ clknet_leaf_39_clk stage3_out\[147\]
+ net468 VSS VSS VDD VDD net202 sky130_fd_sc_hd__dfrtp_1
Xout_flat\[148\]$_DFF_PN0_ clknet_leaf_39_clk stage3_out\[148\]
+ net468 VSS VSS VDD VDD net203 sky130_fd_sc_hd__dfrtp_1
Xout_flat\[149\]$_DFF_PN0_ clknet_leaf_39_clk stage3_out\[149\]
+ net468 VSS VSS VDD VDD net204 sky130_fd_sc_hd__dfrtp_1
Xout_flat\[14\]$_DFF_PN0_ clknet_leaf_42_clk stage3_out\[14\]
+ net161 VSS VSS VDD VDD net205 sky130_fd_sc_hd__dfrtp_1
Xout_flat\[150\]$_DFF_PN0_ clknet_leaf_38_clk stage3_out\[150\]
+ net468 VSS VSS VDD VDD net206 sky130_fd_sc_hd__dfrtp_1
Xout_flat\[151\]$_DFF_PN0_ clknet_leaf_38_clk stage3_out\[151\]
+ net468 VSS VSS VDD VDD net207 sky130_fd_sc_hd__dfrtp_1
Xout_flat\[152\]$_DFF_PN0_ clknet_leaf_37_clk stage3_out\[152\]
+ net468 VSS VSS VDD VDD net208 sky130_fd_sc_hd__dfrtp_1
Xout_flat\[153\]$_DFF_PN0_ clknet_leaf_37_clk stage3_out\[153\]
+ net468 VSS VSS VDD VDD net209 sky130_fd_sc_hd__dfrtp_1
Xout_flat\[154\]$_DFF_PN0_ clknet_leaf_37_clk stage3_out\[154\]
+ net468 VSS VSS VDD VDD net210 sky130_fd_sc_hd__dfrtp_1
Xout_flat\[155\]$_DFF_PN0_ clknet_leaf_38_clk stage3_out\[155\]
+ net468 VSS VSS VDD VDD net211 sky130_fd_sc_hd__dfrtp_1
Xout_flat\[156\]$_DFF_PN0_ clknet_leaf_38_clk stage3_out\[156\]
+ net468 VSS VSS VDD VDD net212 sky130_fd_sc_hd__dfrtp_1
Xout_flat\[157\]$_DFF_PN0_ clknet_leaf_39_clk stage3_out\[157\]
+ net161 VSS VSS VDD VDD net213 sky130_fd_sc_hd__dfrtp_1
Xout_flat\[158\]$_DFF_PN0_ clknet_leaf_39_clk stage3_out\[158\]
+ net468 VSS VSS VDD VDD net214 sky130_fd_sc_hd__dfrtp_1
Xout_flat\[159\]$_DFF_PN0_ clknet_leaf_40_clk stage3_out\[159\]
+ net161 VSS VSS VDD VDD net215 sky130_fd_sc_hd__dfrtp_1
Xout_flat\[15\]$_DFF_PN0_ clknet_leaf_42_clk stage3_out\[15\]
+ net161 VSS VSS VDD VDD net216 sky130_fd_sc_hd__dfrtp_1
Xout_flat\[160\]$_DFF_PN0_ clknet_leaf_16_clk stage3_out\[160\]
+ net460 VSS VSS VDD VDD net217 sky130_fd_sc_hd__dfrtp_1
Xout_flat\[161\]$_DFF_PN0_ clknet_leaf_16_clk stage3_out\[161\]
+ net460 VSS VSS VDD VDD net218 sky130_fd_sc_hd__dfrtp_1
Xout_flat\[162\]$_DFF_PN0_ clknet_leaf_16_clk stage3_out\[162\]
+ net460 VSS VSS VDD VDD net219 sky130_fd_sc_hd__dfrtp_1
Xout_flat\[163\]$_DFF_PN0_ clknet_leaf_16_clk stage3_out\[163\]
+ net460 VSS VSS VDD VDD net220 sky130_fd_sc_hd__dfrtp_1
Xout_flat\[164\]$_DFF_PN0_ clknet_leaf_17_clk stage3_out\[164\]
+ net460 VSS VSS VDD VDD net221 sky130_fd_sc_hd__dfrtp_1
Xout_flat\[165\]$_DFF_PN0_ clknet_leaf_17_clk stage3_out\[165\]
+ net461 VSS VSS VDD VDD net222 sky130_fd_sc_hd__dfrtp_1
Xout_flat\[166\]$_DFF_PN0_ clknet_leaf_17_clk stage3_out\[166\]
+ net460 VSS VSS VDD VDD net223 sky130_fd_sc_hd__dfrtp_1
Xout_flat\[167\]$_DFF_PN0_ clknet_leaf_22_clk stage3_out\[167\]
+ net467 VSS VSS VDD VDD net224 sky130_fd_sc_hd__dfrtp_1
Xout_flat\[168\]$_DFF_PN0_ clknet_leaf_20_clk stage3_out\[168\]
+ net460 VSS VSS VDD VDD net225 sky130_fd_sc_hd__dfrtp_1
Xout_flat\[169\]$_DFF_PN0_ clknet_leaf_22_clk stage3_out\[169\]
+ net467 VSS VSS VDD VDD net226 sky130_fd_sc_hd__dfrtp_1
Xout_flat\[16\]$_DFF_PN0_ clknet_leaf_40_clk stage3_out\[16\]
+ net161 VSS VSS VDD VDD net227 sky130_fd_sc_hd__dfrtp_1
Xout_flat\[170\]$_DFF_PN0_ clknet_leaf_20_clk stage3_out\[170\]
+ net460 VSS VSS VDD VDD net228 sky130_fd_sc_hd__dfrtp_1
Xout_flat\[171\]$_DFF_PN0_ clknet_leaf_20_clk stage3_out\[171\]
+ net460 VSS VSS VDD VDD net229 sky130_fd_sc_hd__dfrtp_1
Xout_flat\[172\]$_DFF_PN0_ clknet_leaf_22_clk stage3_out\[172\]
+ net467 VSS VSS VDD VDD net230 sky130_fd_sc_hd__dfrtp_1
Xout_flat\[173\]$_DFF_PN0_ clknet_leaf_21_clk stage3_out\[173\]
+ net461 VSS VSS VDD VDD net231 sky130_fd_sc_hd__dfrtp_1
Xout_flat\[175\]$_DFF_PN0_ clknet_leaf_22_clk stage3_out\[174\]
+ net467 VSS VSS VDD VDD net233 sky130_fd_sc_hd__dfrtp_1
Xout_flat\[176\]$_DFF_PN0_ clknet_leaf_56_clk stage3_in_r\[177\]
+ net464 VSS VSS VDD VDD net234 sky130_fd_sc_hd__dfrtp_1
Xout_flat\[177\]$_DFF_PN0_ clknet_leaf_56_clk stage3_in_r\[178\]
+ net464 VSS VSS VDD VDD net235 sky130_fd_sc_hd__dfrtp_1
Xout_flat\[178\]$_DFF_PN0_ clknet_leaf_56_clk stage3_in_r\[179\]
+ net464 VSS VSS VDD VDD net236 sky130_fd_sc_hd__dfrtp_1
Xout_flat\[179\]$_DFF_PN0_ clknet_leaf_56_clk stage3_in_r\[180\]
+ net464 VSS VSS VDD VDD net237 sky130_fd_sc_hd__dfrtp_1
Xout_flat\[17\]$_DFF_PN0_ clknet_leaf_43_clk stage3_out\[17\]
+ net161 VSS VSS VDD VDD net238 sky130_fd_sc_hd__dfrtp_1
Xout_flat\[180\]$_DFF_PN0_ clknet_leaf_56_clk stage3_in_r\[181\]
+ net464 VSS VSS VDD VDD net239 sky130_fd_sc_hd__dfrtp_1
Xout_flat\[181\]$_DFF_PN0_ clknet_leaf_54_clk stage3_in_r\[182\]
+ net465 VSS VSS VDD VDD net240 sky130_fd_sc_hd__dfrtp_1
Xout_flat\[182\]$_DFF_PN0_ clknet_leaf_54_clk stage3_in_r\[183\]
+ net465 VSS VSS VDD VDD net241 sky130_fd_sc_hd__dfrtp_1
Xout_flat\[183\]$_DFF_PN0_ clknet_leaf_54_clk stage3_in_r\[184\]
+ net465 VSS VSS VDD VDD net242 sky130_fd_sc_hd__dfrtp_1
Xout_flat\[184\]$_DFF_PN0_ clknet_leaf_15_clk stage3_in_r\[185\]
+ net460 VSS VSS VDD VDD net243 sky130_fd_sc_hd__dfrtp_1
Xout_flat\[185\]$_DFF_PN0_ clknet_leaf_17_clk stage3_in_r\[186\]
+ net461 VSS VSS VDD VDD net244 sky130_fd_sc_hd__dfrtp_1
Xout_flat\[186\]$_DFF_PN0_ clknet_leaf_27_clk stage3_in_r\[187\]
+ net467 VSS VSS VDD VDD net245 sky130_fd_sc_hd__dfrtp_1
Xout_flat\[187\]$_DFF_PN0_ clknet_leaf_27_clk stage3_in_r\[188\]
+ net467 VSS VSS VDD VDD net246 sky130_fd_sc_hd__dfrtp_1
Xout_flat\[188\]$_DFF_PN0_ clknet_leaf_27_clk stage3_in_r\[189\]
+ net467 VSS VSS VDD VDD net247 sky130_fd_sc_hd__dfrtp_1
Xout_flat\[189\]$_DFF_PN0_ clknet_leaf_26_clk stage3_in_r\[190\]
+ net467 VSS VSS VDD VDD net248 sky130_fd_sc_hd__dfrtp_1
Xout_flat\[18\]$_DFF_PN0_ clknet_leaf_40_clk stage3_out\[18\]
+ net161 VSS VSS VDD VDD net249 sky130_fd_sc_hd__dfrtp_1
Xout_flat\[191\]$_DFF_PN0_ clknet_leaf_28_clk stage3_in_r\[191\]
+ net467 VSS VSS VDD VDD net251 sky130_fd_sc_hd__dfrtp_1
Xout_flat\[192\]$_DFF_PN0_ clknet_leaf_48_clk stage3_out\[192\]
+ net466 VSS VSS VDD VDD net252 sky130_fd_sc_hd__dfrtp_1
Xout_flat\[193\]$_DFF_PN0_ clknet_leaf_48_clk stage3_out\[193\]
+ net466 VSS VSS VDD VDD net253 sky130_fd_sc_hd__dfrtp_1
Xout_flat\[194\]$_DFF_PN0_ clknet_leaf_47_clk stage3_out\[194\]
+ net466 VSS VSS VDD VDD net254 sky130_fd_sc_hd__dfrtp_1
Xout_flat\[195\]$_DFF_PN0_ clknet_leaf_47_clk stage3_out\[195\]
+ net466 VSS VSS VDD VDD net255 sky130_fd_sc_hd__dfrtp_1
Xout_flat\[196\]$_DFF_PN0_ clknet_leaf_47_clk stage3_out\[196\]
+ net466 VSS VSS VDD VDD net256 sky130_fd_sc_hd__dfrtp_1
Xout_flat\[197\]$_DFF_PN0_ clknet_leaf_46_clk stage3_out\[197\]
+ net466 VSS VSS VDD VDD net257 sky130_fd_sc_hd__dfrtp_1
Xout_flat\[198\]$_DFF_PN0_ clknet_leaf_46_clk stage3_out\[198\]
+ net466 VSS VSS VDD VDD net258 sky130_fd_sc_hd__dfrtp_1
Xout_flat\[199\]$_DFF_PN0_ clknet_leaf_44_clk stage3_out\[199\]
+ net466 VSS VSS VDD VDD net259 sky130_fd_sc_hd__dfrtp_1
Xout_flat\[19\]$_DFF_PN0_ clknet_leaf_39_clk stage3_out\[19\]
+ net161 VSS VSS VDD VDD net260 sky130_fd_sc_hd__dfrtp_1
Xout_flat\[1\]$_DFF_PN0_ clknet_leaf_51_clk stage3_out\[1\]
+ net466 VSS VSS VDD VDD net261 sky130_fd_sc_hd__dfrtp_1
Xout_flat\[200\]$_DFF_PN0_ clknet_leaf_43_clk stage3_out\[200\]
+ net466 VSS VSS VDD VDD net262 sky130_fd_sc_hd__dfrtp_1
Xout_flat\[201\]$_DFF_PN0_ clknet_leaf_43_clk stage3_out\[201\]
+ net466 VSS VSS VDD VDD net263 sky130_fd_sc_hd__dfrtp_1
Xout_flat\[202\]$_DFF_PN0_ clknet_leaf_41_clk stage3_out\[202\]
+ net161 VSS VSS VDD VDD net264 sky130_fd_sc_hd__dfrtp_1
Xout_flat\[203\]$_DFF_PN0_ clknet_leaf_40_clk stage3_out\[203\]
+ net161 VSS VSS VDD VDD net265 sky130_fd_sc_hd__dfrtp_1
Xout_flat\[204\]$_DFF_PN0_ clknet_leaf_41_clk stage3_out\[204\]
+ net161 VSS VSS VDD VDD net266 sky130_fd_sc_hd__dfrtp_1
Xout_flat\[205\]$_DFF_PN0_ clknet_leaf_41_clk stage3_out\[205\]
+ net161 VSS VSS VDD VDD net267 sky130_fd_sc_hd__dfrtp_1
Xout_flat\[206\]$_DFF_PN0_ clknet_leaf_41_clk stage3_out\[206\]
+ net161 VSS VSS VDD VDD net268 sky130_fd_sc_hd__dfrtp_1
Xout_flat\[207\]$_DFF_PN0_ clknet_leaf_41_clk stage3_out\[207\]
+ net161 VSS VSS VDD VDD net269 sky130_fd_sc_hd__dfrtp_1
Xout_flat\[208\]$_DFF_PN0_ clknet_leaf_34_clk stage3_out\[208\]
+ net468 VSS VSS VDD VDD net270 sky130_fd_sc_hd__dfrtp_1
Xout_flat\[209\]$_DFF_PN0_ clknet_leaf_35_clk stage3_out\[209\]
+ net468 VSS VSS VDD VDD net271 sky130_fd_sc_hd__dfrtp_1
Xout_flat\[20\]$_DFF_PN0_ clknet_leaf_38_clk stage3_out\[20\]
+ net468 VSS VSS VDD VDD net272 sky130_fd_sc_hd__dfrtp_1
Xout_flat\[210\]$_DFF_PN0_ clknet_leaf_35_clk stage3_out\[210\]
+ net468 VSS VSS VDD VDD net273 sky130_fd_sc_hd__dfrtp_1
Xout_flat\[211\]$_DFF_PN0_ clknet_leaf_35_clk stage3_out\[211\]
+ net468 VSS VSS VDD VDD net274 sky130_fd_sc_hd__dfrtp_1
Xout_flat\[212\]$_DFF_PN0_ clknet_leaf_34_clk stage3_out\[212\]
+ net468 VSS VSS VDD VDD net275 sky130_fd_sc_hd__dfrtp_1
Xout_flat\[213\]$_DFF_PN0_ clknet_leaf_35_clk stage3_out\[213\]
+ net468 VSS VSS VDD VDD net276 sky130_fd_sc_hd__dfrtp_1
Xout_flat\[214\]$_DFF_PN0_ clknet_leaf_35_clk stage3_out\[214\]
+ net468 VSS VSS VDD VDD net277 sky130_fd_sc_hd__dfrtp_1
Xout_flat\[215\]$_DFF_PN0_ clknet_leaf_34_clk stage3_out\[215\]
+ net468 VSS VSS VDD VDD net278 sky130_fd_sc_hd__dfrtp_1
Xout_flat\[216\]$_DFF_PN0_ clknet_leaf_34_clk stage3_out\[216\]
+ net468 VSS VSS VDD VDD net279 sky130_fd_sc_hd__dfrtp_1
Xout_flat\[217\]$_DFF_PN0_ clknet_leaf_34_clk stage3_out\[217\]
+ net468 VSS VSS VDD VDD net280 sky130_fd_sc_hd__dfrtp_1
Xout_flat\[218\]$_DFF_PN0_ clknet_leaf_34_clk stage3_out\[218\]
+ net468 VSS VSS VDD VDD net281 sky130_fd_sc_hd__dfrtp_1
Xout_flat\[219\]$_DFF_PN0_ clknet_leaf_33_clk stage3_out\[219\]
+ net468 VSS VSS VDD VDD net282 sky130_fd_sc_hd__dfrtp_1
Xout_flat\[21\]$_DFF_PN0_ clknet_leaf_38_clk stage3_out\[21\]
+ net468 VSS VSS VDD VDD net283 sky130_fd_sc_hd__dfrtp_1
Xout_flat\[220\]$_DFF_PN0_ clknet_leaf_33_clk stage3_out\[220\]
+ net468 VSS VSS VDD VDD net284 sky130_fd_sc_hd__dfrtp_1
Xout_flat\[221\]$_DFF_PN0_ clknet_leaf_33_clk stage3_out\[221\]
+ net468 VSS VSS VDD VDD net285 sky130_fd_sc_hd__dfrtp_1
Xout_flat\[222\]$_DFF_PN0_ clknet_leaf_33_clk stage3_out\[222\]
+ net468 VSS VSS VDD VDD net286 sky130_fd_sc_hd__dfrtp_1
Xout_flat\[223\]$_DFF_PN0_ clknet_leaf_33_clk stage3_out\[223\]
+ net468 VSS VSS VDD VDD net287 sky130_fd_sc_hd__dfrtp_1
Xout_flat\[22\]$_DFF_PN0_ clknet_leaf_38_clk stage3_out\[22\]
+ net468 VSS VSS VDD VDD net288 sky130_fd_sc_hd__dfrtp_1
Xout_flat\[23\]$_DFF_PN0_ clknet_leaf_38_clk stage3_out\[23\]
+ net468 VSS VSS VDD VDD net289 sky130_fd_sc_hd__dfrtp_1
Xout_flat\[240\]$_DFF_PN0_ clknet_leaf_3_clk stage3_out\[240\]
+ net465 VSS VSS VDD VDD net290 sky130_fd_sc_hd__dfrtp_1
Xout_flat\[241\]$_DFF_PN0_ clknet_leaf_3_clk stage3_out\[241\]
+ net465 VSS VSS VDD VDD net291 sky130_fd_sc_hd__dfrtp_1
Xout_flat\[242\]$_DFF_PN0_ clknet_leaf_3_clk stage3_out\[242\]
+ net465 VSS VSS VDD VDD net292 sky130_fd_sc_hd__dfrtp_1
Xout_flat\[243\]$_DFF_PN0_ clknet_leaf_4_clk stage3_out\[243\]
+ net460 VSS VSS VDD VDD net293 sky130_fd_sc_hd__dfrtp_1
Xout_flat\[244\]$_DFF_PN0_ clknet_leaf_4_clk stage3_out\[244\]
+ net460 VSS VSS VDD VDD net294 sky130_fd_sc_hd__dfrtp_1
Xout_flat\[245\]$_DFF_PN0_ clknet_leaf_4_clk stage3_out\[245\]
+ net460 VSS VSS VDD VDD net295 sky130_fd_sc_hd__dfrtp_1
Xout_flat\[246\]$_DFF_PN0_ clknet_leaf_9_clk stage3_out\[246\]
+ net463 VSS VSS VDD VDD net296 sky130_fd_sc_hd__dfrtp_1
Xout_flat\[247\]$_DFF_PN0_ clknet_leaf_15_clk stage3_out\[247\]
+ net460 VSS VSS VDD VDD net297 sky130_fd_sc_hd__dfrtp_1
Xout_flat\[248\]$_DFF_PN0_ clknet_leaf_14_clk stage3_out\[248\]
+ net460 VSS VSS VDD VDD net298 sky130_fd_sc_hd__dfrtp_1
Xout_flat\[249\]$_DFF_PN0_ clknet_leaf_23_clk stage3_out\[249\]
+ net467 VSS VSS VDD VDD net299 sky130_fd_sc_hd__dfrtp_1
Xout_flat\[24\]$_DFF_PN0_ clknet_leaf_37_clk stage3_out\[24\]
+ net468 VSS VSS VDD VDD net300 sky130_fd_sc_hd__dfrtp_1
Xout_flat\[250\]$_DFF_PN0_ clknet_leaf_23_clk stage3_out\[250\]
+ net467 VSS VSS VDD VDD net301 sky130_fd_sc_hd__dfrtp_1
Xout_flat\[251\]$_DFF_PN0_ clknet_leaf_25_clk stage3_out\[251\]
+ net462 VSS VSS VDD VDD net302 sky130_fd_sc_hd__dfrtp_1
Xout_flat\[252\]$_DFF_PN0_ clknet_leaf_27_clk stage3_out\[252\]
+ net467 VSS VSS VDD VDD net303 sky130_fd_sc_hd__dfrtp_1
Xout_flat\[253\]$_DFF_PN0_ clknet_leaf_23_clk stage3_out\[253\]
+ net467 VSS VSS VDD VDD net304 sky130_fd_sc_hd__dfrtp_1
Xout_flat\[254\]$_DFF_PN0_ clknet_leaf_24_clk stage3_out\[254\]
+ net467 VSS VSS VDD VDD net305 sky130_fd_sc_hd__dfrtp_1
Xout_flat\[255\]$_DFF_PN0_ clknet_leaf_24_clk stage3_out\[255\]
+ net467 VSS VSS VDD VDD net306 sky130_fd_sc_hd__dfrtp_1
Xout_flat\[25\]$_DFF_PN0_ clknet_leaf_37_clk stage3_out\[25\]
+ net468 VSS VSS VDD VDD net307 sky130_fd_sc_hd__dfrtp_1
Xout_flat\[26\]$_DFF_PN0_ clknet_leaf_37_clk stage3_out\[26\]
+ net468 VSS VSS VDD VDD net308 sky130_fd_sc_hd__dfrtp_1
Xout_flat\[27\]$_DFF_PN0_ clknet_leaf_38_clk stage3_out\[27\]
+ net468 VSS VSS VDD VDD net309 sky130_fd_sc_hd__dfrtp_1
Xout_flat\[28\]$_DFF_PN0_ clknet_leaf_38_clk stage3_out\[28\]
+ net468 VSS VSS VDD VDD net310 sky130_fd_sc_hd__dfrtp_1
Xout_flat\[29\]$_DFF_PN0_ clknet_leaf_41_clk stage3_out\[29\]
+ net161 VSS VSS VDD VDD net311 sky130_fd_sc_hd__dfrtp_1
Xout_flat\[2\]$_DFF_PN0_ clknet_leaf_47_clk stage3_out\[2\]
+ net466 VSS VSS VDD VDD net312 sky130_fd_sc_hd__dfrtp_1
Xout_flat\[30\]$_DFF_PN0_ clknet_leaf_38_clk stage3_out\[30\]
+ net468 VSS VSS VDD VDD net313 sky130_fd_sc_hd__dfrtp_1
Xout_flat\[31\]$_DFF_PN0_ clknet_leaf_40_clk stage3_out\[31\]
+ net161 VSS VSS VDD VDD net314 sky130_fd_sc_hd__dfrtp_1
Xout_flat\[32\]$_DFF_PN0_ clknet_leaf_16_clk stage3_out\[32\]
+ net460 VSS VSS VDD VDD net315 sky130_fd_sc_hd__dfrtp_1
Xout_flat\[33\]$_DFF_PN0_ clknet_leaf_16_clk stage3_in_r\[50\]
+ net460 VSS VSS VDD VDD net316 sky130_fd_sc_hd__dfrtp_1
Xout_flat\[34\]$_DFF_PN0_ clknet_leaf_16_clk stage3_out\[34\]
+ net460 VSS VSS VDD VDD net317 sky130_fd_sc_hd__dfrtp_1
Xout_flat\[35\]$_DFF_PN0_ clknet_leaf_16_clk stage3_out\[35\]
+ net461 VSS VSS VDD VDD net318 sky130_fd_sc_hd__dfrtp_1
Xout_flat\[36\]$_DFF_PN0_ clknet_leaf_17_clk stage3_out\[36\]
+ net460 VSS VSS VDD VDD net319 sky130_fd_sc_hd__dfrtp_1
Xout_flat\[37\]$_DFF_PN0_ clknet_leaf_17_clk stage3_out\[37\]
+ net461 VSS VSS VDD VDD net320 sky130_fd_sc_hd__dfrtp_1
Xout_flat\[38\]$_DFF_PN0_ clknet_leaf_20_clk stage3_out\[38\]
+ net460 VSS VSS VDD VDD net321 sky130_fd_sc_hd__dfrtp_1
Xout_flat\[39\]$_DFF_PN0_ clknet_leaf_20_clk stage3_out\[39\]
+ net461 VSS VSS VDD VDD net322 sky130_fd_sc_hd__dfrtp_1
Xout_flat\[3\]$_DFF_PN0_ clknet_leaf_47_clk stage3_out\[3\]
+ net466 VSS VSS VDD VDD net323 sky130_fd_sc_hd__dfrtp_1
Xout_flat\[40\]$_DFF_PN0_ clknet_leaf_20_clk stage3_out\[40\]
+ net460 VSS VSS VDD VDD net324 sky130_fd_sc_hd__dfrtp_1
Xout_flat\[41\]$_DFF_PN0_ clknet_leaf_20_clk stage3_out\[41\]
+ net461 VSS VSS VDD VDD net325 sky130_fd_sc_hd__dfrtp_1
Xout_flat\[42\]$_DFF_PN0_ clknet_leaf_20_clk stage3_out\[42\]
+ net460 VSS VSS VDD VDD net326 sky130_fd_sc_hd__dfrtp_1
Xout_flat\[43\]$_DFF_PN0_ clknet_leaf_20_clk stage3_out\[43\]
+ net460 VSS VSS VDD VDD net327 sky130_fd_sc_hd__dfrtp_1
Xout_flat\[44\]$_DFF_PN0_ clknet_leaf_22_clk stage3_out\[44\]
+ net461 VSS VSS VDD VDD net328 sky130_fd_sc_hd__dfrtp_1
Xout_flat\[45\]$_DFF_PN0_ clknet_leaf_21_clk stage3_out\[45\]
+ net460 VSS VSS VDD VDD net329 sky130_fd_sc_hd__dfrtp_1
Xout_flat\[46\]$_DFF_PN0_ clknet_leaf_22_clk stage3_out\[46\]
+ net467 VSS VSS VDD VDD net330 sky130_fd_sc_hd__dfrtp_1
Xout_flat\[47\]$_DFF_PN0_ clknet_leaf_21_clk stage3_out\[47\]
+ net461 VSS VSS VDD VDD net331 sky130_fd_sc_hd__dfrtp_1
Xout_flat\[4\]$_DFF_PN0_ clknet_leaf_47_clk stage3_out\[4\]
+ net466 VSS VSS VDD VDD net334 sky130_fd_sc_hd__dfrtp_1
Xout_flat\[5\]$_DFF_PN0_ clknet_leaf_46_clk stage3_out\[5\]
+ net466 VSS VSS VDD VDD net345 sky130_fd_sc_hd__dfrtp_1
Xout_flat\[64\]$_DFF_PN0_ clknet_leaf_47_clk stage3_out\[64\]
+ net466 VSS VSS VDD VDD net350 sky130_fd_sc_hd__dfrtp_1
Xout_flat\[65\]$_DFF_PN0_ clknet_leaf_48_clk stage3_out\[65\]
+ net466 VSS VSS VDD VDD net351 sky130_fd_sc_hd__dfrtp_1
Xout_flat\[66\]$_DFF_PN0_ clknet_leaf_47_clk stage3_out\[66\]
+ net466 VSS VSS VDD VDD net352 sky130_fd_sc_hd__dfrtp_1
Xout_flat\[67\]$_DFF_PN0_ clknet_leaf_47_clk stage3_out\[67\]
+ net466 VSS VSS VDD VDD net353 sky130_fd_sc_hd__dfrtp_1
Xout_flat\[68\]$_DFF_PN0_ clknet_leaf_46_clk stage3_out\[68\]
+ net466 VSS VSS VDD VDD net354 sky130_fd_sc_hd__dfrtp_1
Xout_flat\[69\]$_DFF_PN0_ clknet_leaf_46_clk stage3_out\[69\]
+ net466 VSS VSS VDD VDD net355 sky130_fd_sc_hd__dfrtp_1
Xout_flat\[6\]$_DFF_PN0_ clknet_leaf_46_clk stage3_out\[6\]
+ net466 VSS VSS VDD VDD net356 sky130_fd_sc_hd__dfrtp_1
Xout_flat\[70\]$_DFF_PN0_ clknet_leaf_46_clk stage3_out\[70\]
+ net466 VSS VSS VDD VDD net357 sky130_fd_sc_hd__dfrtp_1
Xout_flat\[71\]$_DFF_PN0_ clknet_leaf_44_clk stage3_out\[71\]
+ net466 VSS VSS VDD VDD net358 sky130_fd_sc_hd__dfrtp_1
Xout_flat\[72\]$_DFF_PN0_ clknet_leaf_44_clk stage3_out\[72\]
+ net466 VSS VSS VDD VDD net359 sky130_fd_sc_hd__dfrtp_1
Xout_flat\[73\]$_DFF_PN0_ clknet_leaf_43_clk stage3_out\[73\]
+ net466 VSS VSS VDD VDD net360 sky130_fd_sc_hd__dfrtp_1
Xout_flat\[74\]$_DFF_PN0_ clknet_leaf_43_clk stage3_out\[74\]
+ net161 VSS VSS VDD VDD net361 sky130_fd_sc_hd__dfrtp_1
Xout_flat\[75\]$_DFF_PN0_ clknet_leaf_41_clk stage3_out\[75\]
+ net161 VSS VSS VDD VDD net362 sky130_fd_sc_hd__dfrtp_1
Xout_flat\[76\]$_DFF_PN0_ clknet_leaf_41_clk stage3_out\[76\]
+ net161 VSS VSS VDD VDD net363 sky130_fd_sc_hd__dfrtp_1
Xout_flat\[77\]$_DFF_PN0_ clknet_leaf_41_clk stage3_out\[77\]
+ net161 VSS VSS VDD VDD net364 sky130_fd_sc_hd__dfrtp_1
Xout_flat\[78\]$_DFF_PN0_ clknet_leaf_41_clk stage3_out\[78\]
+ net161 VSS VSS VDD VDD net365 sky130_fd_sc_hd__dfrtp_1
Xout_flat\[79\]$_DFF_PN0_ clknet_leaf_41_clk stage3_out\[79\]
+ net161 VSS VSS VDD VDD net366 sky130_fd_sc_hd__dfrtp_1
Xout_flat\[7\]$_DFF_PN0_ clknet_leaf_44_clk stage3_out\[7\]
+ net466 VSS VSS VDD VDD net367 sky130_fd_sc_hd__dfrtp_1
Xout_flat\[80\]$_DFF_PN0_ clknet_leaf_35_clk stage3_out\[80\]
+ net468 VSS VSS VDD VDD net368 sky130_fd_sc_hd__dfrtp_1
Xout_flat\[81\]$_DFF_PN0_ clknet_leaf_35_clk stage3_out\[81\]
+ net468 VSS VSS VDD VDD net369 sky130_fd_sc_hd__dfrtp_1
Xout_flat\[82\]$_DFF_PN0_ clknet_leaf_36_clk stage3_out\[82\]
+ net468 VSS VSS VDD VDD net370 sky130_fd_sc_hd__dfrtp_1
Xout_flat\[83\]$_DFF_PN0_ clknet_leaf_35_clk stage3_out\[83\]
+ net468 VSS VSS VDD VDD net371 sky130_fd_sc_hd__dfrtp_1
Xout_flat\[84\]$_DFF_PN0_ clknet_leaf_34_clk stage3_out\[84\]
+ net468 VSS VSS VDD VDD net372 sky130_fd_sc_hd__dfrtp_1
Xout_flat\[85\]$_DFF_PN0_ clknet_leaf_35_clk stage3_out\[85\]
+ net468 VSS VSS VDD VDD net373 sky130_fd_sc_hd__dfrtp_1
Xout_flat\[86\]$_DFF_PN0_ clknet_leaf_35_clk stage3_out\[86\]
+ net468 VSS VSS VDD VDD net374 sky130_fd_sc_hd__dfrtp_1
Xout_flat\[87\]$_DFF_PN0_ clknet_leaf_34_clk stage3_out\[87\]
+ net468 VSS VSS VDD VDD net375 sky130_fd_sc_hd__dfrtp_1
Xout_flat\[88\]$_DFF_PN0_ clknet_leaf_34_clk stage3_out\[88\]
+ net468 VSS VSS VDD VDD net376 sky130_fd_sc_hd__dfrtp_1
Xout_flat\[89\]$_DFF_PN0_ clknet_leaf_34_clk stage3_out\[89\]
+ net468 VSS VSS VDD VDD net377 sky130_fd_sc_hd__dfrtp_1
Xout_flat\[8\]$_DFF_PN0_ clknet_leaf_44_clk stage3_out\[8\]
+ net466 VSS VSS VDD VDD net378 sky130_fd_sc_hd__dfrtp_1
Xout_flat\[90\]$_DFF_PN0_ clknet_leaf_34_clk stage3_out\[90\]
+ net468 VSS VSS VDD VDD net379 sky130_fd_sc_hd__dfrtp_1
Xout_flat\[91\]$_DFF_PN0_ clknet_leaf_33_clk stage3_out\[91\]
+ net468 VSS VSS VDD VDD net380 sky130_fd_sc_hd__dfrtp_1
Xout_flat\[92\]$_DFF_PN0_ clknet_leaf_32_clk stage3_out\[92\]
+ net468 VSS VSS VDD VDD net381 sky130_fd_sc_hd__dfrtp_1
Xout_flat\[93\]$_DFF_PN0_ clknet_leaf_33_clk stage3_out\[93\]
+ net468 VSS VSS VDD VDD net382 sky130_fd_sc_hd__dfrtp_1
Xout_flat\[94\]$_DFF_PN0_ clknet_leaf_32_clk stage3_out\[94\]
+ net468 VSS VSS VDD VDD net383 sky130_fd_sc_hd__dfrtp_1
Xout_flat\[95\]$_DFF_PN0_ clknet_leaf_32_clk stage3_out\[95\]
+ net468 VSS VSS VDD VDD net384 sky130_fd_sc_hd__dfrtp_1
Xout_flat\[9\]$_DFF_PN0_ clknet_leaf_43_clk stage3_out\[9\]
+ net466 VSS VSS VDD VDD net385 sky130_fd_sc_hd__dfrtp_1
Xout_valid$_DFF_PN0_ clknet_leaf_57_clk v3 net464 VSS VSS
+ VDD VDD net386 sky130_fd_sc_hd__dfrtp_1
Xstage1_in_r\[112\]$_DFF_PN0_ clknet_leaf_5_clk net155 net460
+ VSS VSS VDD VDD stage1_in_r\[112\] sky130_fd_sc_hd__dfrtp_1
Xstage1_in_r\[113\]$_DFF_PN0_ clknet_leaf_5_clk net156 net460
+ VSS VSS VDD VDD stage1_in_r\[113\] sky130_fd_sc_hd__dfrtp_1
Xstage1_in_r\[114\]$_DFF_PN0_ clknet_leaf_5_clk net157 net460
+ VSS VSS VDD VDD stage1_in_r\[114\] sky130_fd_sc_hd__dfrtp_1
Xstage1_in_r\[115\]$_DFF_PN0_ clknet_leaf_5_clk net158 net460
+ VSS VSS VDD VDD stage1_in_r\[115\] sky130_fd_sc_hd__dfrtp_1
Xstage1_in_r\[116\]$_DFF_PN0_ clknet_leaf_15_clk net33 net460
+ VSS VSS VDD VDD stage1_in_r\[116\] sky130_fd_sc_hd__dfrtp_1
Xstage1_in_r\[117\]$_DFF_PN0_ clknet_leaf_15_clk net34 net460
+ VSS VSS VDD VDD stage1_in_r\[117\] sky130_fd_sc_hd__dfrtp_1
Xstage1_in_r\[118\]$_DFF_PN0_ clknet_leaf_16_clk net35 net460
+ VSS VSS VDD VDD stage1_in_r\[118\] sky130_fd_sc_hd__dfrtp_1
Xstage1_in_r\[119\]$_DFF_PN0_ clknet_leaf_21_clk net36 net461
+ VSS VSS VDD VDD stage1_in_r\[119\] sky130_fd_sc_hd__dfrtp_1
Xstage1_in_r\[120\]$_DFF_PN0_ clknet_leaf_21_clk net37 net461
+ VSS VSS VDD VDD stage1_in_r\[120\] sky130_fd_sc_hd__dfrtp_1
Xstage1_in_r\[121\]$_DFF_PN0_ clknet_leaf_21_clk net38 net461
+ VSS VSS VDD VDD stage1_in_r\[121\] sky130_fd_sc_hd__dfrtp_1
Xstage1_in_r\[122\]$_DFF_PN0_ clknet_leaf_22_clk net39 net461
+ VSS VSS VDD VDD stage1_in_r\[122\] sky130_fd_sc_hd__dfrtp_1
Xstage1_in_r\[123\]$_DFF_PN0_ clknet_leaf_21_clk net40 net467
+ VSS VSS VDD VDD stage1_in_r\[123\] sky130_fd_sc_hd__dfrtp_1
Xstage1_in_r\[124\]$_DFF_PN0_ clknet_leaf_22_clk net41 net467
+ VSS VSS VDD VDD stage1_in_r\[124\] sky130_fd_sc_hd__dfrtp_1
Xstage1_in_r\[125\]$_DFF_PN0_ clknet_leaf_23_clk net42 net467
+ VSS VSS VDD VDD stage1_in_r\[125\] sky130_fd_sc_hd__dfrtp_1
Xstage1_in_r\[126\]$_DFF_PN0_ clknet_leaf_23_clk net44 net467
+ VSS VSS VDD VDD stage1_in_r\[126\] sky130_fd_sc_hd__dfrtp_1
Xstage1_in_r\[127\]$_DFF_PN0_ clknet_leaf_22_clk net45 net467
+ VSS VSS VDD VDD stage1_in_r\[127\] sky130_fd_sc_hd__dfrtp_1
Xstage1_in_r\[144\]$_DFF_PN0_ clknet_leaf_53_clk net67 net464
+ VSS VSS VDD VDD stage1_in_r\[144\] sky130_fd_sc_hd__dfrtp_1
Xstage1_in_r\[145\]$_DFF_PN0_ clknet_leaf_55_clk net68 net464
+ VSS VSS VDD VDD stage1_in_r\[145\] sky130_fd_sc_hd__dfrtp_1
Xstage1_in_r\[146\]$_DFF_PN0_ clknet_leaf_55_clk net69 net464
+ VSS VSS VDD VDD stage1_in_r\[146\] sky130_fd_sc_hd__dfrtp_1
Xstage1_in_r\[147\]$_DFF_PN0_ clknet_leaf_56_clk net70 net464
+ VSS VSS VDD VDD stage1_in_r\[147\] sky130_fd_sc_hd__dfrtp_1
Xstage1_in_r\[148\]$_DFF_PN0_ clknet_leaf_57_clk net72 net464
+ VSS VSS VDD VDD stage1_in_r\[148\] sky130_fd_sc_hd__dfrtp_1
Xstage1_in_r\[149\]$_DFF_PN0_ clknet_leaf_57_clk net73 net464
+ VSS VSS VDD VDD stage1_in_r\[149\] sky130_fd_sc_hd__dfrtp_1
Xstage1_in_r\[150\]$_DFF_PN0_ clknet_leaf_56_clk net74 net464
+ VSS VSS VDD VDD stage1_in_r\[150\] sky130_fd_sc_hd__dfrtp_1
Xstage1_in_r\[151\]$_DFF_PN0_ clknet_leaf_57_clk net75 net464
+ VSS VSS VDD VDD stage1_in_r\[151\] sky130_fd_sc_hd__dfrtp_1
Xstage1_in_r\[152\]$_DFF_PN0_ clknet_leaf_55_clk net76 net464
+ VSS VSS VDD VDD stage1_in_r\[152\] sky130_fd_sc_hd__dfrtp_1
Xstage1_in_r\[153\]$_DFF_PN0_ clknet_leaf_55_clk net77 net464
+ VSS VSS VDD VDD stage1_in_r\[153\] sky130_fd_sc_hd__dfrtp_1
Xstage1_in_r\[154\]$_DFF_PN0_ clknet_leaf_55_clk net78 net464
+ VSS VSS VDD VDD stage1_in_r\[154\] sky130_fd_sc_hd__dfrtp_1
Xstage1_in_r\[155\]$_DFF_PN0_ clknet_leaf_53_clk net79 net464
+ VSS VSS VDD VDD stage1_in_r\[155\] sky130_fd_sc_hd__dfrtp_1
Xstage1_in_r\[156\]$_DFF_PN0_ clknet_leaf_53_clk net80 net464
+ VSS VSS VDD VDD stage1_in_r\[156\] sky130_fd_sc_hd__dfrtp_1
Xstage1_in_r\[157\]$_DFF_PN0_ clknet_leaf_52_clk net81 net464
+ VSS VSS VDD VDD stage1_in_r\[157\] sky130_fd_sc_hd__dfrtp_1
Xstage1_in_r\[158\]$_DFF_PN0_ clknet_leaf_52_clk net83 net465
+ VSS VSS VDD VDD stage1_in_r\[158\] sky130_fd_sc_hd__dfrtp_1
Xstage1_in_r\[159\]$_DFF_PN0_ clknet_leaf_53_clk net84 net464
+ VSS VSS VDD VDD stage1_in_r\[159\] sky130_fd_sc_hd__dfrtp_1
Xstage1_in_r\[16\]$_DFF_PN0_ clknet_leaf_5_clk net32 net460
+ VSS VSS VDD VDD stage1_in_r\[16\] sky130_fd_sc_hd__dfrtp_1
Xstage1_in_r\[176\]$_DFF_PN0_ clknet_leaf_53_clk net138 net464
+ VSS VSS VDD VDD stage1_in_r\[176\] sky130_fd_sc_hd__dfrtp_1
Xstage1_in_r\[177\]$_DFF_PN0_ clknet_leaf_55_clk net139 net464
+ VSS VSS VDD VDD stage1_in_r\[177\] sky130_fd_sc_hd__dfrtp_1
Xstage1_in_r\[178\]$_DFF_PN0_ clknet_leaf_55_clk net140 net464
+ VSS VSS VDD VDD stage1_in_r\[178\] sky130_fd_sc_hd__dfrtp_1
Xstage1_in_r\[179\]$_DFF_PN0_ clknet_leaf_56_clk net141 net464
+ VSS VSS VDD VDD stage1_in_r\[179\] sky130_fd_sc_hd__dfrtp_1
Xstage1_in_r\[17\]$_DFF_PN0_ clknet_leaf_6_clk net71 net460
+ VSS VSS VDD VDD stage1_in_r\[17\] sky130_fd_sc_hd__dfrtp_1
Xstage1_in_r\[180\]$_DFF_PN0_ clknet_leaf_57_clk net142 net464
+ VSS VSS VDD VDD stage1_in_r\[180\] sky130_fd_sc_hd__dfrtp_1
Xstage1_in_r\[181\]$_DFF_PN0_ clknet_leaf_56_clk net143 net464
+ VSS VSS VDD VDD stage1_in_r\[181\] sky130_fd_sc_hd__dfrtp_1
Xstage1_in_r\[182\]$_DFF_PN0_ clknet_leaf_58_clk net144 net464
+ VSS VSS VDD VDD stage1_in_r\[182\] sky130_fd_sc_hd__dfrtp_1
Xstage1_in_r\[183\]$_DFF_PN0_ clknet_leaf_56_clk net145 net464
+ VSS VSS VDD VDD stage1_in_r\[183\] sky130_fd_sc_hd__dfrtp_1
Xstage1_in_r\[184\]$_DFF_PN0_ clknet_leaf_55_clk net146 net464
+ VSS VSS VDD VDD stage1_in_r\[184\] sky130_fd_sc_hd__dfrtp_1
Xstage1_in_r\[185\]$_DFF_PN0_ clknet_leaf_55_clk net147 net464
+ VSS VSS VDD VDD stage1_in_r\[185\] sky130_fd_sc_hd__dfrtp_1
Xstage1_in_r\[186\]$_DFF_PN0_ clknet_leaf_55_clk net149 net464
+ VSS VSS VDD VDD stage1_in_r\[186\] sky130_fd_sc_hd__dfrtp_1
Xstage1_in_r\[187\]$_DFF_PN0_ clknet_leaf_53_clk net150 net464
+ VSS VSS VDD VDD stage1_in_r\[187\] sky130_fd_sc_hd__dfrtp_1
Xstage1_in_r\[188\]$_DFF_PN0_ clknet_leaf_53_clk net151 net464
+ VSS VSS VDD VDD stage1_in_r\[188\] sky130_fd_sc_hd__dfrtp_1
Xstage1_in_r\[189\]$_DFF_PN0_ clknet_leaf_53_clk net152 net464
+ VSS VSS VDD VDD stage1_in_r\[189\] sky130_fd_sc_hd__dfrtp_1
Xstage1_in_r\[18\]$_DFF_PN0_ clknet_leaf_5_clk net82 net460
+ VSS VSS VDD VDD stage1_in_r\[18\] sky130_fd_sc_hd__dfrtp_1
Xstage1_in_r\[190\]$_DFF_PN0_ clknet_leaf_52_clk net153 net465
+ VSS VSS VDD VDD stage1_in_r\[190\] sky130_fd_sc_hd__dfrtp_1
Xstage1_in_r\[191\]$_DFF_PN0_ clknet_leaf_53_clk net154 net465
+ VSS VSS VDD VDD stage1_in_r\[191\] sky130_fd_sc_hd__dfrtp_1
Xstage1_in_r\[19\]$_DFF_PN0_ clknet_leaf_5_clk net93 net460
+ VSS VSS VDD VDD stage1_in_r\[19\] sky130_fd_sc_hd__dfrtp_1
Xstage1_in_r\[208\]$_DFF_PN0_ clknet_leaf_57_clk net102 net464
+ VSS VSS VDD VDD stage1_in_r\[208\] sky130_fd_sc_hd__dfrtp_1
Xstage1_in_r\[209\]$_DFF_PN0_ clknet_leaf_57_clk net103 net464
+ VSS VSS VDD VDD stage1_in_r\[209\] sky130_fd_sc_hd__dfrtp_1
Xstage1_in_r\[20\]$_DFF_PN0_ clknet_leaf_5_clk net104 net460
+ VSS VSS VDD VDD stage1_in_r\[20\] sky130_fd_sc_hd__dfrtp_1
Xstage1_in_r\[210\]$_DFF_PN0_ clknet_leaf_58_clk net105 net464
+ VSS VSS VDD VDD stage1_in_r\[210\] sky130_fd_sc_hd__dfrtp_1
Xstage1_in_r\[211\]$_DFF_PN0_ clknet_leaf_58_clk net106 net464
+ VSS VSS VDD VDD stage1_in_r\[211\] sky130_fd_sc_hd__dfrtp_1
Xstage1_in_r\[212\]$_DFF_PN0_ clknet_leaf_58_clk net107 net464
+ VSS VSS VDD VDD stage1_in_r\[212\] sky130_fd_sc_hd__dfrtp_1
Xstage1_in_r\[213\]$_DFF_PN0_ clknet_leaf_0_clk net108 net464
+ VSS VSS VDD VDD stage1_in_r\[213\] sky130_fd_sc_hd__dfrtp_1
Xstage1_in_r\[214\]$_DFF_PN0_ clknet_leaf_0_clk net109 net464
+ VSS VSS VDD VDD stage1_in_r\[214\] sky130_fd_sc_hd__dfrtp_1
Xstage1_in_r\[215\]$_DFF_PN0_ clknet_leaf_0_clk net110 net464
+ VSS VSS VDD VDD stage1_in_r\[215\] sky130_fd_sc_hd__dfrtp_1
Xstage1_in_r\[216\]$_DFF_PN0_ clknet_leaf_3_clk net111 net465
+ VSS VSS VDD VDD stage1_in_r\[216\] sky130_fd_sc_hd__dfrtp_1
Xstage1_in_r\[217\]$_DFF_PN0_ clknet_leaf_4_clk net112 net460
+ VSS VSS VDD VDD stage1_in_r\[217\] sky130_fd_sc_hd__dfrtp_1
Xstage1_in_r\[218\]$_DFF_PN0_ clknet_leaf_4_clk net113 net460
+ VSS VSS VDD VDD stage1_in_r\[218\] sky130_fd_sc_hd__dfrtp_1
Xstage1_in_r\[219\]$_DFF_PN0_ clknet_leaf_7_clk net114 net463
+ VSS VSS VDD VDD stage1_in_r\[219\] sky130_fd_sc_hd__dfrtp_1
Xstage1_in_r\[21\]$_DFF_PN0_ clknet_leaf_14_clk net115 net460
+ VSS VSS VDD VDD stage1_in_r\[21\] sky130_fd_sc_hd__dfrtp_1
Xstage1_in_r\[220\]$_DFF_PN0_ clknet_leaf_28_clk net116 net467
+ VSS VSS VDD VDD stage1_in_r\[220\] sky130_fd_sc_hd__dfrtp_1
Xstage1_in_r\[221\]$_DFF_PN0_ clknet_leaf_27_clk net117 net467
+ VSS VSS VDD VDD stage1_in_r\[221\] sky130_fd_sc_hd__dfrtp_1
Xstage1_in_r\[222\]$_DFF_PN0_ clknet_leaf_27_clk net118 net467
+ VSS VSS VDD VDD stage1_in_r\[222\] sky130_fd_sc_hd__dfrtp_1
Xstage1_in_r\[223\]$_DFF_PN0_ clknet_leaf_27_clk net119 net467
+ VSS VSS VDD VDD stage1_in_r\[223\] sky130_fd_sc_hd__dfrtp_1
Xstage1_in_r\[22\]$_DFF_PN0_ clknet_leaf_14_clk net126 net461
+ VSS VSS VDD VDD stage1_in_r\[22\] sky130_fd_sc_hd__dfrtp_1
Xstage1_in_r\[23\]$_DFF_PN0_ clknet_leaf_15_clk net137 net460
+ VSS VSS VDD VDD stage1_in_r\[23\] sky130_fd_sc_hd__dfrtp_1
Xstage1_in_r\[240\]$_DFF_PN0_ clknet_leaf_57_clk net46 net464
+ VSS VSS VDD VDD stage1_in_r\[240\] sky130_fd_sc_hd__dfrtp_1
Xstage1_in_r\[241\]$_DFF_PN0_ clknet_leaf_57_clk net47 net464
+ VSS VSS VDD VDD stage1_in_r\[241\] sky130_fd_sc_hd__dfrtp_1
Xstage1_in_r\[242\]$_DFF_PN0_ clknet_leaf_57_clk net48 net464
+ VSS VSS VDD VDD stage1_in_r\[242\] sky130_fd_sc_hd__dfrtp_1
Xstage1_in_r\[243\]$_DFF_PN0_ clknet_leaf_58_clk net49 net464
+ VSS VSS VDD VDD stage1_in_r\[243\] sky130_fd_sc_hd__dfrtp_1
Xstage1_in_r\[244\]$_DFF_PN0_ clknet_leaf_0_clk net50 net464
+ VSS VSS VDD VDD stage1_in_r\[244\] sky130_fd_sc_hd__dfrtp_1
Xstage1_in_r\[245\]$_DFF_PN0_ clknet_leaf_0_clk net51 net464
+ VSS VSS VDD VDD stage1_in_r\[245\] sky130_fd_sc_hd__dfrtp_1
Xstage1_in_r\[246\]$_DFF_PN0_ clknet_leaf_0_clk net52 net464
+ VSS VSS VDD VDD stage1_in_r\[246\] sky130_fd_sc_hd__dfrtp_1
Xstage1_in_r\[247\]$_DFF_PN0_ clknet_leaf_0_clk net53 net464
+ VSS VSS VDD VDD stage1_in_r\[247\] sky130_fd_sc_hd__dfrtp_1
Xstage1_in_r\[248\]$_DFF_PN0_ clknet_leaf_3_clk net55 net465
+ VSS VSS VDD VDD stage1_in_r\[248\] sky130_fd_sc_hd__dfrtp_1
Xstage1_in_r\[249\]$_DFF_PN0_ clknet_leaf_4_clk net56 net465
+ VSS VSS VDD VDD stage1_in_r\[249\] sky130_fd_sc_hd__dfrtp_1
Xstage1_in_r\[24\]$_DFF_PN0_ clknet_leaf_16_clk net148 net461
+ VSS VSS VDD VDD stage1_in_r\[24\] sky130_fd_sc_hd__dfrtp_1
Xstage1_in_r\[250\]$_DFF_PN0_ clknet_leaf_8_clk net57 net463
+ VSS VSS VDD VDD stage1_in_r\[250\] sky130_fd_sc_hd__dfrtp_1
Xstage1_in_r\[251\]$_DFF_PN0_ clknet_leaf_7_clk net58 net463
+ VSS VSS VDD VDD stage1_in_r\[251\] sky130_fd_sc_hd__dfrtp_1
Xstage1_in_r\[252\]$_DFF_PN0_ clknet_leaf_28_clk net59 net467
+ VSS VSS VDD VDD stage1_in_r\[252\] sky130_fd_sc_hd__dfrtp_1
Xstage1_in_r\[253\]$_DFF_PN0_ clknet_leaf_27_clk net60 net467
+ VSS VSS VDD VDD stage1_in_r\[253\] sky130_fd_sc_hd__dfrtp_1
Xstage1_in_r\[254\]$_DFF_PN0_ clknet_leaf_27_clk net61 net467
+ VSS VSS VDD VDD stage1_in_r\[254\] sky130_fd_sc_hd__dfrtp_1
Xstage1_in_r\[255\]$_DFF_PN0_ clknet_leaf_27_clk net62 net467
+ VSS VSS VDD VDD stage1_in_r\[255\] sky130_fd_sc_hd__dfrtp_1
Xstage1_in_r\[25\]$_DFF_PN0_ clknet_leaf_17_clk net159 net461
+ VSS VSS VDD VDD stage1_in_r\[25\] sky130_fd_sc_hd__dfrtp_1
Xstage1_in_r\[26\]$_DFF_PN0_ clknet_leaf_13_clk net43 net462
+ VSS VSS VDD VDD stage1_in_r\[26\] sky130_fd_sc_hd__dfrtp_1
Xstage1_in_r\[27\]$_DFF_PN0_ clknet_leaf_23_clk net54 net467
+ VSS VSS VDD VDD stage1_in_r\[27\] sky130_fd_sc_hd__dfrtp_1
Xstage1_in_r\[28\]$_DFF_PN0_ clknet_leaf_23_clk net63 net467
+ VSS VSS VDD VDD stage1_in_r\[28\] sky130_fd_sc_hd__dfrtp_1
Xstage1_in_r\[29\]$_DFF_PN0_ clknet_leaf_25_clk net64 net462
+ VSS VSS VDD VDD stage1_in_r\[29\] sky130_fd_sc_hd__dfrtp_1
Xstage1_in_r\[30\]$_DFF_PN0_ clknet_leaf_26_clk net65 net467
+ VSS VSS VDD VDD stage1_in_r\[30\] sky130_fd_sc_hd__dfrtp_1
Xstage1_in_r\[31\]$_DFF_PN0_ clknet_leaf_26_clk net66 net467
+ VSS VSS VDD VDD stage1_in_r\[31\] sky130_fd_sc_hd__dfrtp_1
Xstage1_in_r\[48\]$_DFF_PN0_ clknet_leaf_5_clk net120 net460
+ VSS VSS VDD VDD stage1_in_r\[48\] sky130_fd_sc_hd__dfrtp_1
Xstage1_in_r\[49\]$_DFF_PN0_ clknet_leaf_5_clk net121 net460
+ VSS VSS VDD VDD stage1_in_r\[49\] sky130_fd_sc_hd__dfrtp_1
Xstage1_in_r\[50\]$_DFF_PN0_ clknet_leaf_6_clk net122 net460
+ VSS VSS VDD VDD stage1_in_r\[50\] sky130_fd_sc_hd__dfrtp_1
Xstage1_in_r\[51\]$_DFF_PN0_ clknet_leaf_6_clk net123 net460
+ VSS VSS VDD VDD stage1_in_r\[51\] sky130_fd_sc_hd__dfrtp_1
Xstage1_in_r\[52\]$_DFF_PN0_ clknet_leaf_5_clk net124 net460
+ VSS VSS VDD VDD stage1_in_r\[52\] sky130_fd_sc_hd__dfrtp_1
Xstage1_in_r\[53\]$_DFF_PN0_ clknet_leaf_15_clk net125 net460
+ VSS VSS VDD VDD stage1_in_r\[53\] sky130_fd_sc_hd__dfrtp_1
Xstage1_in_r\[54\]$_DFF_PN0_ clknet_leaf_14_clk net127 net461
+ VSS VSS VDD VDD stage1_in_r\[54\] sky130_fd_sc_hd__dfrtp_1
Xstage1_in_r\[55\]$_DFF_PN0_ clknet_leaf_15_clk net128 net460
+ VSS VSS VDD VDD stage1_in_r\[55\] sky130_fd_sc_hd__dfrtp_1
Xstage1_in_r\[56\]$_DFF_PN0_ clknet_leaf_18_clk net129 net461
+ VSS VSS VDD VDD stage1_in_r\[56\] sky130_fd_sc_hd__dfrtp_1
Xstage1_in_r\[57\]$_DFF_PN0_ clknet_leaf_18_clk net130 net461
+ VSS VSS VDD VDD stage1_in_r\[57\] sky130_fd_sc_hd__dfrtp_1
Xstage1_in_r\[58\]$_DFF_PN0_ clknet_leaf_13_clk net131 net462
+ VSS VSS VDD VDD stage1_in_r\[58\] sky130_fd_sc_hd__dfrtp_1
Xstage1_in_r\[59\]$_DFF_PN0_ clknet_leaf_23_clk net132 net467
+ VSS VSS VDD VDD stage1_in_r\[59\] sky130_fd_sc_hd__dfrtp_1
Xstage1_in_r\[60\]$_DFF_PN0_ clknet_leaf_23_clk net133 net467
+ VSS VSS VDD VDD stage1_in_r\[60\] sky130_fd_sc_hd__dfrtp_1
Xstage1_in_r\[61\]$_DFF_PN0_ clknet_leaf_25_clk net134 net462
+ VSS VSS VDD VDD stage1_in_r\[61\] sky130_fd_sc_hd__dfrtp_1
Xstage1_in_r\[62\]$_DFF_PN0_ clknet_leaf_25_clk net135 net462
+ VSS VSS VDD VDD stage1_in_r\[62\] sky130_fd_sc_hd__dfrtp_1
Xstage1_in_r\[63\]$_DFF_PN0_ clknet_leaf_26_clk net136 net467
+ VSS VSS VDD VDD stage1_in_r\[63\] sky130_fd_sc_hd__dfrtp_1
Xstage1_in_r\[80\]$_DFF_PN0_ clknet_leaf_4_clk net85 net460
+ VSS VSS VDD VDD stage1_in_r\[80\] sky130_fd_sc_hd__dfrtp_1
Xstage1_in_r\[81\]$_DFF_PN0_ clknet_leaf_5_clk net86 net460
+ VSS VSS VDD VDD stage1_in_r\[81\] sky130_fd_sc_hd__dfrtp_1
Xstage1_in_r\[82\]$_DFF_PN0_ clknet_leaf_5_clk net87 net460
+ VSS VSS VDD VDD stage1_in_r\[82\] sky130_fd_sc_hd__dfrtp_1
Xstage1_in_r\[83\]$_DFF_PN0_ clknet_leaf_5_clk net88 net460
+ VSS VSS VDD VDD stage1_in_r\[83\] sky130_fd_sc_hd__dfrtp_1
Xstage1_in_r\[84\]$_DFF_PN0_ clknet_leaf_15_clk net89 net460
+ VSS VSS VDD VDD stage1_in_r\[84\] sky130_fd_sc_hd__dfrtp_1
Xstage1_in_r\[85\]$_DFF_PN0_ clknet_leaf_15_clk net90 net460
+ VSS VSS VDD VDD stage1_in_r\[85\] sky130_fd_sc_hd__dfrtp_1
Xstage1_in_r\[86\]$_DFF_PN0_ clknet_leaf_15_clk net91 net460
+ VSS VSS VDD VDD stage1_in_r\[86\] sky130_fd_sc_hd__dfrtp_1
Xstage1_in_r\[87\]$_DFF_PN0_ clknet_leaf_21_clk net92 net461
+ VSS VSS VDD VDD stage1_in_r\[87\] sky130_fd_sc_hd__dfrtp_1
Xstage1_in_r\[88\]$_DFF_PN0_ clknet_leaf_21_clk net94 net461
+ VSS VSS VDD VDD stage1_in_r\[88\] sky130_fd_sc_hd__dfrtp_1
Xstage1_in_r\[89\]$_DFF_PN0_ clknet_leaf_21_clk net95 net461
+ VSS VSS VDD VDD stage1_in_r\[89\] sky130_fd_sc_hd__dfrtp_1
Xstage1_in_r\[90\]$_DFF_PN0_ clknet_leaf_21_clk net96 net461
+ VSS VSS VDD VDD stage1_in_r\[90\] sky130_fd_sc_hd__dfrtp_1
Xstage1_in_r\[91\]$_DFF_PN0_ clknet_leaf_22_clk net97 net467
+ VSS VSS VDD VDD stage1_in_r\[91\] sky130_fd_sc_hd__dfrtp_1
Xstage1_in_r\[92\]$_DFF_PN0_ clknet_leaf_22_clk net98 net467
+ VSS VSS VDD VDD stage1_in_r\[92\] sky130_fd_sc_hd__dfrtp_1
Xstage1_in_r\[93\]$_DFF_PN0_ clknet_leaf_23_clk net99 net467
+ VSS VSS VDD VDD stage1_in_r\[93\] sky130_fd_sc_hd__dfrtp_1
Xstage1_in_r\[94\]$_DFF_PN0_ clknet_leaf_23_clk net100 net467
+ VSS VSS VDD VDD stage1_in_r\[94\] sky130_fd_sc_hd__dfrtp_1
Xstage1_in_r\[95\]$_DFF_PN0_ clknet_leaf_22_clk net101 net467
+ VSS VSS VDD VDD stage1_in_r\[95\] sky130_fd_sc_hd__dfrtp_1
Xstage2_in_r\[112\]$_DFF_PN0_ clknet_leaf_6_clk stage1_out\[112\]
+ net461 VSS VSS VDD VDD stage2_in_r\[112\] sky130_fd_sc_hd__dfrtp_1
Xstage2_in_r\[113\]$_DFF_PN0_ clknet_leaf_6_clk stage1_out\[113\]
+ net461 VSS VSS VDD VDD stage2_in_r\[113\] sky130_fd_sc_hd__dfrtp_1
Xstage2_in_r\[114\]$_DFF_PN0_ clknet_leaf_6_clk stage1_out\[114\]
+ net461 VSS VSS VDD VDD stage2_in_r\[114\] sky130_fd_sc_hd__dfrtp_1
Xstage2_in_r\[115\]$_DFF_PN0_ clknet_leaf_14_clk stage1_out\[115\]
+ net461 VSS VSS VDD VDD stage2_in_r\[115\] sky130_fd_sc_hd__dfrtp_1
Xstage2_in_r\[116\]$_DFF_PN0_ clknet_leaf_14_clk stage1_out\[116\]
+ net461 VSS VSS VDD VDD stage2_in_r\[116\] sky130_fd_sc_hd__dfrtp_1
Xstage2_in_r\[117\]$_DFF_PN0_ clknet_leaf_16_clk stage1_out\[117\]
+ net461 VSS VSS VDD VDD stage2_in_r\[117\] sky130_fd_sc_hd__dfrtp_1
Xstage2_in_r\[118\]$_DFF_PN0_ clknet_leaf_17_clk stage1_out\[118\]
+ net461 VSS VSS VDD VDD stage2_in_r\[118\] sky130_fd_sc_hd__dfrtp_1
Xstage2_in_r\[119\]$_DFF_PN0_ clknet_leaf_21_clk stage1_out\[119\]
+ net461 VSS VSS VDD VDD stage2_in_r\[119\] sky130_fd_sc_hd__dfrtp_1
Xstage2_in_r\[120\]$_DFF_PN0_ clknet_leaf_19_clk stage1_out\[120\]
+ net461 VSS VSS VDD VDD stage2_in_r\[120\] sky130_fd_sc_hd__dfrtp_1
Xstage2_in_r\[121\]$_DFF_PN0_ clknet_leaf_19_clk stage1_out\[121\]
+ net461 VSS VSS VDD VDD stage2_in_r\[121\] sky130_fd_sc_hd__dfrtp_1
Xstage2_in_r\[122\]$_DFF_PN0_ clknet_leaf_19_clk stage1_out\[122\]
+ net461 VSS VSS VDD VDD stage2_in_r\[122\] sky130_fd_sc_hd__dfrtp_1
Xstage2_in_r\[123\]$_DFF_PN0_ clknet_leaf_19_clk stage1_out\[123\]
+ net461 VSS VSS VDD VDD stage2_in_r\[123\] sky130_fd_sc_hd__dfrtp_1
Xstage2_in_r\[124\]$_DFF_PN0_ clknet_leaf_24_clk stage1_out\[124\]
+ net462 VSS VSS VDD VDD stage2_in_r\[124\] sky130_fd_sc_hd__dfrtp_1
Xstage2_in_r\[125\]$_DFF_PN0_ clknet_leaf_23_clk stage1_out\[125\]
+ net462 VSS VSS VDD VDD stage2_in_r\[125\] sky130_fd_sc_hd__dfrtp_1
Xstage2_in_r\[126\]$_DFF_PN0_ clknet_leaf_24_clk stage1_out\[126\]
+ net462 VSS VSS VDD VDD stage2_in_r\[126\] sky130_fd_sc_hd__dfrtp_1
Xstage2_in_r\[127\]$_DFF_PN0_ clknet_leaf_19_clk stage1_out\[127\]
+ net462 VSS VSS VDD VDD stage2_in_r\[127\] sky130_fd_sc_hd__dfrtp_1
Xstage2_in_r\[144\]$_DFF_PN0_ clknet_leaf_52_clk stage1_out\[144\]
+ net465 VSS VSS VDD VDD stage2_in_r\[144\] sky130_fd_sc_hd__dfrtp_1
Xstage2_in_r\[145\]$_DFF_PN0_ clknet_leaf_51_clk stage1_out\[145\]
+ net465 VSS VSS VDD VDD stage2_in_r\[145\] sky130_fd_sc_hd__dfrtp_1
Xstage2_in_r\[146\]$_DFF_PN0_ clknet_leaf_51_clk stage1_out\[146\]
+ net465 VSS VSS VDD VDD stage2_in_r\[146\] sky130_fd_sc_hd__dfrtp_1
Xstage2_in_r\[147\]$_DFF_PN0_ clknet_leaf_52_clk stage1_out\[147\]
+ net465 VSS VSS VDD VDD stage2_in_r\[147\] sky130_fd_sc_hd__dfrtp_1
Xstage2_in_r\[148\]$_DFF_PN0_ clknet_leaf_52_clk stage1_out\[148\]
+ net465 VSS VSS VDD VDD stage2_in_r\[148\] sky130_fd_sc_hd__dfrtp_1
Xstage2_in_r\[149\]$_DFF_PN0_ clknet_leaf_52_clk stage1_out\[149\]
+ net465 VSS VSS VDD VDD stage2_in_r\[149\] sky130_fd_sc_hd__dfrtp_1
Xstage2_in_r\[150\]$_DFF_PN0_ clknet_leaf_54_clk stage1_out\[150\]
+ net465 VSS VSS VDD VDD stage2_in_r\[150\] sky130_fd_sc_hd__dfrtp_1
Xstage2_in_r\[151\]$_DFF_PN0_ clknet_leaf_51_clk stage1_out\[151\]
+ net465 VSS VSS VDD VDD stage2_in_r\[151\] sky130_fd_sc_hd__dfrtp_1
Xstage2_in_r\[152\]$_DFF_PN0_ clknet_leaf_54_clk stage1_out\[152\]
+ net465 VSS VSS VDD VDD stage2_in_r\[152\] sky130_fd_sc_hd__dfrtp_1
Xstage2_in_r\[153\]$_DFF_PN0_ clknet_leaf_52_clk stage1_out\[153\]
+ net465 VSS VSS VDD VDD stage2_in_r\[153\] sky130_fd_sc_hd__dfrtp_1
Xstage2_in_r\[154\]$_DFF_PN0_ clknet_leaf_51_clk stage1_out\[154\]
+ net465 VSS VSS VDD VDD stage2_in_r\[154\] sky130_fd_sc_hd__dfrtp_1
Xstage2_in_r\[155\]$_DFF_PN0_ clknet_leaf_52_clk stage1_out\[155\]
+ net465 VSS VSS VDD VDD stage2_in_r\[155\] sky130_fd_sc_hd__dfrtp_1
Xstage2_in_r\[156\]$_DFF_PN0_ clknet_leaf_51_clk stage1_out\[156\]
+ net465 VSS VSS VDD VDD stage2_in_r\[156\] sky130_fd_sc_hd__dfrtp_1
Xstage2_in_r\[157\]$_DFF_PN0_ clknet_leaf_51_clk stage1_out\[157\]
+ net465 VSS VSS VDD VDD stage2_in_r\[157\] sky130_fd_sc_hd__dfrtp_1
Xstage2_in_r\[158\]$_DFF_PN0_ clknet_leaf_52_clk stage1_out\[158\]
+ net465 VSS VSS VDD VDD stage2_in_r\[158\] sky130_fd_sc_hd__dfrtp_1
Xstage2_in_r\[159\]$_DFF_PN0_ clknet_leaf_51_clk stage1_out\[159\]
+ net465 VSS VSS VDD VDD stage2_in_r\[159\] sky130_fd_sc_hd__dfrtp_1
Xstage2_in_r\[16\]$_DFF_PN0_ clknet_leaf_7_clk stage1_out\[16\]
+ net463 VSS VSS VDD VDD stage2_in_r\[16\] sky130_fd_sc_hd__dfrtp_1
Xstage2_in_r\[176\]$_DFF_PN0_ clknet_leaf_55_clk stage1_out\[176\]
+ net464 VSS VSS VDD VDD stage2_in_r\[176\] sky130_fd_sc_hd__dfrtp_1
Xstage2_in_r\[177\]$_DFF_PN0_ clknet_leaf_55_clk stage1_out\[177\]
+ net464 VSS VSS VDD VDD stage2_in_r\[177\] sky130_fd_sc_hd__dfrtp_1
Xstage2_in_r\[178\]$_DFF_PN0_ clknet_leaf_54_clk stage1_out\[178\]
+ net464 VSS VSS VDD VDD stage2_in_r\[178\] sky130_fd_sc_hd__dfrtp_1
Xstage2_in_r\[179\]$_DFF_PN0_ clknet_leaf_54_clk stage1_out\[179\]
+ net465 VSS VSS VDD VDD stage2_in_r\[179\] sky130_fd_sc_hd__dfrtp_1
Xstage2_in_r\[17\]$_DFF_PN0_ clknet_leaf_7_clk stage1_out\[17\]
+ net463 VSS VSS VDD VDD stage2_in_r\[17\] sky130_fd_sc_hd__dfrtp_1
Xstage2_in_r\[180\]$_DFF_PN0_ clknet_leaf_1_clk stage1_out\[180\]
+ net465 VSS VSS VDD VDD stage2_in_r\[180\] sky130_fd_sc_hd__dfrtp_1
Xstage2_in_r\[181\]$_DFF_PN0_ clknet_leaf_1_clk stage1_out\[181\]
+ net465 VSS VSS VDD VDD stage2_in_r\[181\] sky130_fd_sc_hd__dfrtp_1
Xstage2_in_r\[182\]$_DFF_PN0_ clknet_leaf_1_clk stage1_out\[182\]
+ net465 VSS VSS VDD VDD stage2_in_r\[182\] sky130_fd_sc_hd__dfrtp_1
Xstage2_in_r\[183\]$_DFF_PN0_ clknet_leaf_54_clk stage1_out\[183\]
+ net463 VSS VSS VDD VDD stage2_in_r\[183\] sky130_fd_sc_hd__dfrtp_1
Xstage2_in_r\[184\]$_DFF_PN0_ clknet_leaf_54_clk stage1_out\[184\]
+ net463 VSS VSS VDD VDD stage2_in_r\[184\] sky130_fd_sc_hd__dfrtp_1
Xstage2_in_r\[185\]$_DFF_PN0_ clknet_leaf_54_clk stage1_out\[185\]
+ net465 VSS VSS VDD VDD stage2_in_r\[185\] sky130_fd_sc_hd__dfrtp_1
Xstage2_in_r\[186\]$_DFF_PN0_ clknet_leaf_10_clk stage1_out\[186\]
+ net463 VSS VSS VDD VDD stage2_in_r\[186\] sky130_fd_sc_hd__dfrtp_1
Xstage2_in_r\[187\]$_DFF_PN0_ clknet_leaf_11_clk stage1_out\[187\]
+ net462 VSS VSS VDD VDD stage2_in_r\[187\] sky130_fd_sc_hd__dfrtp_1
Xstage2_in_r\[188\]$_DFF_PN0_ clknet_leaf_30_clk stage1_out\[188\]
+ net462 VSS VSS VDD VDD stage2_in_r\[188\] sky130_fd_sc_hd__dfrtp_1
Xstage2_in_r\[189\]$_DFF_PN0_ clknet_leaf_30_clk stage1_out\[189\]
+ net462 VSS VSS VDD VDD stage2_in_r\[189\] sky130_fd_sc_hd__dfrtp_1
Xstage2_in_r\[18\]$_DFF_PN0_ clknet_leaf_7_clk stage1_out\[18\]
+ net463 VSS VSS VDD VDD stage2_in_r\[18\] sky130_fd_sc_hd__dfrtp_1
Xstage2_in_r\[190\]$_DFF_PN0_ clknet_leaf_31_clk net424 net463
+ VSS VSS VDD VDD stage2_in_r\[190\] sky130_fd_sc_hd__dfrtp_1
Xstage2_in_r\[191\]$_DFF_PN0_ clknet_leaf_30_clk stage1_out\[191\]
+ net462 VSS VSS VDD VDD stage2_in_r\[191\] sky130_fd_sc_hd__dfrtp_1
Xstage2_in_r\[19\]$_DFF_PN0_ clknet_leaf_13_clk stage1_out\[19\]
+ net463 VSS VSS VDD VDD stage2_in_r\[19\] sky130_fd_sc_hd__dfrtp_1
Xstage2_in_r\[209\]$_DFF_PN0_ clknet_leaf_51_clk stage1_out\[209\]
+ net465 VSS VSS VDD VDD stage2_in_r\[209\] sky130_fd_sc_hd__dfrtp_1
Xstage2_in_r\[20\]$_DFF_PN0_ clknet_leaf_13_clk stage1_out\[20\]
+ net462 VSS VSS VDD VDD stage2_in_r\[20\] sky130_fd_sc_hd__dfrtp_1
Xstage2_in_r\[210\]$_DFF_PN0_ clknet_leaf_1_clk stage1_out\[210\]
+ net465 VSS VSS VDD VDD stage2_in_r\[210\] sky130_fd_sc_hd__dfrtp_1
Xstage2_in_r\[211\]$_DFF_PN0_ clknet_leaf_1_clk stage1_out\[211\]
+ net465 VSS VSS VDD VDD stage2_in_r\[211\] sky130_fd_sc_hd__dfrtp_1
Xstage2_in_r\[212\]$_DFF_PN0_ clknet_leaf_2_clk stage1_out\[212\]
+ net463 VSS VSS VDD VDD stage2_in_r\[212\] sky130_fd_sc_hd__dfrtp_1
Xstage2_in_r\[213\]$_DFF_PN0_ clknet_leaf_2_clk stage1_out\[213\]
+ net463 VSS VSS VDD VDD stage2_in_r\[213\] sky130_fd_sc_hd__dfrtp_1
Xstage2_in_r\[214\]$_DFF_PN0_ clknet_leaf_2_clk stage1_out\[214\]
+ net465 VSS VSS VDD VDD stage2_in_r\[214\] sky130_fd_sc_hd__dfrtp_1
Xstage2_in_r\[215\]$_DFF_PN0_ clknet_leaf_2_clk stage1_out\[215\]
+ net463 VSS VSS VDD VDD stage2_in_r\[215\] sky130_fd_sc_hd__dfrtp_1
Xstage2_in_r\[216\]$_DFF_PN0_ clknet_leaf_8_clk stage1_out\[216\]
+ net463 VSS VSS VDD VDD stage2_in_r\[216\] sky130_fd_sc_hd__dfrtp_1
Xstage2_in_r\[217\]$_DFF_PN0_ clknet_leaf_9_clk stage1_out\[217\]
+ net463 VSS VSS VDD VDD stage2_in_r\[217\] sky130_fd_sc_hd__dfrtp_1
Xstage2_in_r\[218\]$_DFF_PN0_ clknet_leaf_9_clk stage1_out\[218\]
+ net463 VSS VSS VDD VDD stage2_in_r\[218\] sky130_fd_sc_hd__dfrtp_1
Xstage2_in_r\[219\]$_DFF_PN0_ clknet_leaf_29_clk stage1_out\[219\]
+ net467 VSS VSS VDD VDD stage2_in_r\[219\] sky130_fd_sc_hd__dfrtp_1
Xstage2_in_r\[21\]$_DFF_PN0_ clknet_leaf_13_clk stage1_out\[21\]
+ net462 VSS VSS VDD VDD stage2_in_r\[21\] sky130_fd_sc_hd__dfrtp_1
Xstage2_in_r\[220\]$_DFF_PN0_ clknet_leaf_33_clk stage1_out\[220\]
+ net468 VSS VSS VDD VDD stage2_in_r\[220\] sky130_fd_sc_hd__dfrtp_1
Xstage2_in_r\[221\]$_DFF_PN0_ clknet_leaf_32_clk stage1_out\[221\]
+ net468 VSS VSS VDD VDD stage2_in_r\[221\] sky130_fd_sc_hd__dfrtp_1
Xstage2_in_r\[222\]$_DFF_PN0_ clknet_leaf_29_clk stage1_out\[222\]
+ net467 VSS VSS VDD VDD stage2_in_r\[222\] sky130_fd_sc_hd__dfrtp_1
Xstage2_in_r\[223\]$_DFF_PN0_ clknet_leaf_28_clk stage1_out\[223\]
+ net467 VSS VSS VDD VDD stage2_in_r\[223\] sky130_fd_sc_hd__dfrtp_1
Xstage2_in_r\[22\]$_DFF_PN0_ clknet_leaf_13_clk stage1_out\[22\]
+ net462 VSS VSS VDD VDD stage2_in_r\[22\] sky130_fd_sc_hd__dfrtp_1
Xstage2_in_r\[23\]$_DFF_PN0_ clknet_leaf_13_clk stage1_out\[23\]
+ net462 VSS VSS VDD VDD stage2_in_r\[23\] sky130_fd_sc_hd__dfrtp_1
Xstage2_in_r\[240\]$_DFF_PN0_ clknet_leaf_58_clk stage1_out\[240\]
+ net464 VSS VSS VDD VDD stage2_in_r\[240\] sky130_fd_sc_hd__dfrtp_1
Xstage2_in_r\[241\]$_DFF_PN0_ clknet_leaf_58_clk stage1_out\[241\]
+ net464 VSS VSS VDD VDD stage2_in_r\[241\] sky130_fd_sc_hd__dfrtp_1
Xstage2_in_r\[242\]$_DFF_PN0_ clknet_leaf_58_clk stage1_out\[242\]
+ net464 VSS VSS VDD VDD stage2_in_r\[242\] sky130_fd_sc_hd__dfrtp_1
Xstage2_in_r\[243\]$_DFF_PN0_ clknet_leaf_58_clk stage1_out\[243\]
+ net464 VSS VSS VDD VDD stage2_in_r\[243\] sky130_fd_sc_hd__dfrtp_1
Xstage2_in_r\[244\]$_DFF_PN0_ clknet_leaf_1_clk stage1_out\[244\]
+ net464 VSS VSS VDD VDD stage2_in_r\[244\] sky130_fd_sc_hd__dfrtp_1
Xstage2_in_r\[245\]$_DFF_PN0_ clknet_leaf_0_clk stage1_out\[245\]
+ net465 VSS VSS VDD VDD stage2_in_r\[245\] sky130_fd_sc_hd__dfrtp_1
Xstage2_in_r\[246\]$_DFF_PN0_ clknet_leaf_0_clk stage1_out\[246\]
+ net465 VSS VSS VDD VDD stage2_in_r\[246\] sky130_fd_sc_hd__dfrtp_1
Xstage2_in_r\[247\]$_DFF_PN0_ clknet_leaf_2_clk stage1_out\[247\]
+ net465 VSS VSS VDD VDD stage2_in_r\[247\] sky130_fd_sc_hd__dfrtp_1
Xstage2_in_r\[248\]$_DFF_PN0_ clknet_leaf_8_clk stage1_out\[248\]
+ net463 VSS VSS VDD VDD stage2_in_r\[248\] sky130_fd_sc_hd__dfrtp_1
Xstage2_in_r\[249\]$_DFF_PN0_ clknet_leaf_8_clk stage1_out\[249\]
+ net463 VSS VSS VDD VDD stage2_in_r\[249\] sky130_fd_sc_hd__dfrtp_1
Xstage2_in_r\[24\]$_DFF_PN0_ clknet_leaf_12_clk stage1_out\[24\]
+ net462 VSS VSS VDD VDD stage2_in_r\[24\] sky130_fd_sc_hd__dfrtp_1
Xstage2_in_r\[250\]$_DFF_PN0_ clknet_leaf_10_clk stage1_out\[250\]
+ net463 VSS VSS VDD VDD stage2_in_r\[250\] sky130_fd_sc_hd__dfrtp_1
Xstage2_in_r\[251\]$_DFF_PN0_ clknet_leaf_31_clk stage1_out\[251\]
+ net463 VSS VSS VDD VDD stage2_in_r\[251\] sky130_fd_sc_hd__dfrtp_1
Xstage2_in_r\[252\]$_DFF_PN0_ clknet_leaf_29_clk stage1_out\[252\]
+ net462 VSS VSS VDD VDD stage2_in_r\[252\] sky130_fd_sc_hd__dfrtp_1
Xstage2_in_r\[253\]$_DFF_PN0_ clknet_leaf_29_clk stage1_out\[253\]
+ net467 VSS VSS VDD VDD stage2_in_r\[253\] sky130_fd_sc_hd__dfrtp_1
Xstage2_in_r\[254\]$_DFF_PN0_ clknet_leaf_29_clk stage1_out\[254\]
+ net467 VSS VSS VDD VDD stage2_in_r\[254\] sky130_fd_sc_hd__dfrtp_1
Xstage2_in_r\[255\]$_DFF_PN0_ clknet_leaf_28_clk stage1_out\[255\]
+ net467 VSS VSS VDD VDD stage2_in_r\[255\] sky130_fd_sc_hd__dfrtp_1
Xstage2_in_r\[25\]$_DFF_PN0_ clknet_leaf_11_clk stage1_out\[25\]
+ net462 VSS VSS VDD VDD stage2_in_r\[25\] sky130_fd_sc_hd__dfrtp_1
Xstage2_in_r\[26\]$_DFF_PN0_ clknet_leaf_12_clk stage1_out\[26\]
+ net462 VSS VSS VDD VDD stage2_in_r\[26\] sky130_fd_sc_hd__dfrtp_1
Xstage2_in_r\[27\]$_DFF_PN0_ clknet_leaf_12_clk stage1_out\[27\]
+ net462 VSS VSS VDD VDD stage2_in_r\[27\] sky130_fd_sc_hd__dfrtp_1
Xstage2_in_r\[28\]$_DFF_PN0_ clknet_leaf_12_clk stage1_out\[28\]
+ net462 VSS VSS VDD VDD stage2_in_r\[28\] sky130_fd_sc_hd__dfrtp_1
Xstage2_in_r\[29\]$_DFF_PN0_ clknet_leaf_11_clk stage1_out\[29\]
+ net462 VSS VSS VDD VDD stage2_in_r\[29\] sky130_fd_sc_hd__dfrtp_1
Xstage2_in_r\[30\]$_DFF_PN0_ clknet_leaf_12_clk stage1_out\[30\]
+ net462 VSS VSS VDD VDD stage2_in_r\[30\] sky130_fd_sc_hd__dfrtp_1
Xstage2_in_r\[31\]$_DFF_PN0_ clknet_leaf_12_clk stage1_out\[31\]
+ net462 VSS VSS VDD VDD stage2_in_r\[31\] sky130_fd_sc_hd__dfrtp_1
Xstage2_in_r\[48\]$_DFF_PN0_ clknet_leaf_7_clk stage1_out\[48\]
+ net461 VSS VSS VDD VDD stage2_in_r\[48\] sky130_fd_sc_hd__dfrtp_1
Xstage2_in_r\[49\]$_DFF_PN0_ clknet_leaf_6_clk stage1_out\[49\]
+ net461 VSS VSS VDD VDD stage2_in_r\[49\] sky130_fd_sc_hd__dfrtp_1
Xstage2_in_r\[50\]$_DFF_PN0_ clknet_leaf_6_clk stage1_out\[50\]
+ net461 VSS VSS VDD VDD stage2_in_r\[50\] sky130_fd_sc_hd__dfrtp_1
Xstage2_in_r\[51\]$_DFF_PN0_ clknet_leaf_14_clk stage1_out\[51\]
+ net461 VSS VSS VDD VDD stage2_in_r\[51\] sky130_fd_sc_hd__dfrtp_1
Xstage2_in_r\[52\]$_DFF_PN0_ clknet_leaf_14_clk stage1_out\[52\]
+ net461 VSS VSS VDD VDD stage2_in_r\[52\] sky130_fd_sc_hd__dfrtp_1
Xstage2_in_r\[53\]$_DFF_PN0_ clknet_leaf_14_clk stage1_out\[53\]
+ net461 VSS VSS VDD VDD stage2_in_r\[53\] sky130_fd_sc_hd__dfrtp_1
Xstage2_in_r\[54\]$_DFF_PN0_ clknet_leaf_12_clk stage1_out\[54\]
+ net462 VSS VSS VDD VDD stage2_in_r\[54\] sky130_fd_sc_hd__dfrtp_1
Xstage2_in_r\[55\]$_DFF_PN0_ clknet_leaf_12_clk stage1_out\[55\]
+ net462 VSS VSS VDD VDD stage2_in_r\[55\] sky130_fd_sc_hd__dfrtp_1
Xstage2_in_r\[56\]$_DFF_PN0_ clknet_leaf_12_clk stage1_out\[56\]
+ net462 VSS VSS VDD VDD stage2_in_r\[56\] sky130_fd_sc_hd__dfrtp_1
Xstage2_in_r\[57\]$_DFF_PN0_ clknet_leaf_12_clk stage1_out\[57\]
+ net462 VSS VSS VDD VDD stage2_in_r\[57\] sky130_fd_sc_hd__dfrtp_1
Xstage2_in_r\[58\]$_DFF_PN0_ clknet_leaf_12_clk stage1_out\[58\]
+ net462 VSS VSS VDD VDD stage2_in_r\[58\] sky130_fd_sc_hd__dfrtp_1
Xstage2_in_r\[59\]$_DFF_PN0_ clknet_leaf_18_clk stage1_out\[59\]
+ net462 VSS VSS VDD VDD stage2_in_r\[59\] sky130_fd_sc_hd__dfrtp_1
Xstage2_in_r\[60\]$_DFF_PN0_ clknet_leaf_18_clk stage1_out\[60\]
+ net462 VSS VSS VDD VDD stage2_in_r\[60\] sky130_fd_sc_hd__dfrtp_1
Xstage2_in_r\[61\]$_DFF_PN0_ clknet_leaf_25_clk stage1_out\[61\]
+ net462 VSS VSS VDD VDD stage2_in_r\[61\] sky130_fd_sc_hd__dfrtp_1
Xstage2_in_r\[62\]$_DFF_PN0_ clknet_leaf_25_clk stage1_out\[62\]
+ net462 VSS VSS VDD VDD stage2_in_r\[62\] sky130_fd_sc_hd__dfrtp_1
Xstage2_in_r\[63\]$_DFF_PN0_ clknet_leaf_25_clk stage1_out\[63\]
+ net462 VSS VSS VDD VDD stage2_in_r\[63\] sky130_fd_sc_hd__dfrtp_1
Xstage2_in_r\[81\]$_DFF_PN0_ clknet_leaf_9_clk stage1_out\[81\]
+ net463 VSS VSS VDD VDD stage2_in_r\[81\] sky130_fd_sc_hd__dfrtp_1
Xstage2_in_r\[82\]$_DFF_PN0_ clknet_leaf_11_clk stage1_out\[82\]
+ net463 VSS VSS VDD VDD stage2_in_r\[82\] sky130_fd_sc_hd__dfrtp_1
Xstage2_in_r\[83\]$_DFF_PN0_ clknet_leaf_11_clk stage1_out\[83\]
+ net463 VSS VSS VDD VDD stage2_in_r\[83\] sky130_fd_sc_hd__dfrtp_1
Xstage2_in_r\[84\]$_DFF_PN0_ clknet_leaf_11_clk stage1_out\[84\]
+ net463 VSS VSS VDD VDD stage2_in_r\[84\] sky130_fd_sc_hd__dfrtp_1
Xstage2_in_r\[85\]$_DFF_PN0_ clknet_leaf_11_clk stage1_out\[85\]
+ net463 VSS VSS VDD VDD stage2_in_r\[85\] sky130_fd_sc_hd__dfrtp_1
Xstage2_in_r\[86\]$_DFF_PN0_ clknet_leaf_19_clk stage1_out\[86\]
+ net461 VSS VSS VDD VDD stage2_in_r\[86\] sky130_fd_sc_hd__dfrtp_1
Xstage2_in_r\[87\]$_DFF_PN0_ clknet_leaf_30_clk stage1_out\[87\]
+ net462 VSS VSS VDD VDD stage2_in_r\[87\] sky130_fd_sc_hd__dfrtp_1
Xstage2_in_r\[88\]$_DFF_PN0_ clknet_leaf_31_clk stage1_out\[88\]
+ net462 VSS VSS VDD VDD stage2_in_r\[88\] sky130_fd_sc_hd__dfrtp_1
Xstage2_in_r\[89\]$_DFF_PN0_ clknet_leaf_30_clk stage1_out\[89\]
+ net462 VSS VSS VDD VDD stage2_in_r\[89\] sky130_fd_sc_hd__dfrtp_1
Xstage2_in_r\[90\]$_DFF_PN0_ clknet_leaf_30_clk stage1_out\[90\]
+ net462 VSS VSS VDD VDD stage2_in_r\[90\] sky130_fd_sc_hd__dfrtp_1
Xstage2_in_r\[91\]$_DFF_PN0_ clknet_leaf_30_clk stage1_out\[91\]
+ net462 VSS VSS VDD VDD stage2_in_r\[91\] sky130_fd_sc_hd__dfrtp_1
Xstage2_in_r\[92\]$_DFF_PN0_ clknet_leaf_30_clk stage1_out\[92\]
+ net462 VSS VSS VDD VDD stage2_in_r\[92\] sky130_fd_sc_hd__dfrtp_1
Xstage2_in_r\[93\]$_DFF_PN0_ clknet_leaf_28_clk stage1_out\[93\]
+ net467 VSS VSS VDD VDD stage2_in_r\[93\] sky130_fd_sc_hd__dfrtp_1
Xstage2_in_r\[94\]$_DFF_PN0_ clknet_leaf_26_clk stage1_out\[94\]
+ net467 VSS VSS VDD VDD stage2_in_r\[94\] sky130_fd_sc_hd__dfrtp_1
Xstage2_in_r\[95\]$_DFF_PN0_ clknet_leaf_28_clk stage1_out\[95\]
+ net467 VSS VSS VDD VDD stage2_in_r\[95\] sky130_fd_sc_hd__dfrtp_1
Xstage3_in_r\[0\]$_DFF_PN0_ clknet_leaf_10_clk stage2_out\[0\]
+ net463 VSS VSS VDD VDD stage3_in_r\[0\] sky130_fd_sc_hd__dfrtp_1
Xstage3_in_r\[10\]$_DFF_PN0_ clknet_leaf_8_clk stage2_out\[10\]
+ net463 VSS VSS VDD VDD stage3_in_r\[10\] sky130_fd_sc_hd__dfrtp_1
Xstage3_in_r\[112\]$_DFF_PN0_ clknet_leaf_2_clk stage2_out\[112\]
+ net465 VSS VSS VDD VDD stage3_in_r\[112\] sky130_fd_sc_hd__dfrtp_1
Xstage3_in_r\[113\]$_DFF_PN0_ clknet_leaf_3_clk stage2_out\[113\]
+ net460 VSS VSS VDD VDD stage3_in_r\[113\] sky130_fd_sc_hd__dfrtp_1
Xstage3_in_r\[114\]$_DFF_PN0_ clknet_leaf_2_clk stage2_out\[114\]
+ net465 VSS VSS VDD VDD stage3_in_r\[114\] sky130_fd_sc_hd__dfrtp_1
Xstage3_in_r\[115\]$_DFF_PN0_ clknet_leaf_8_clk stage2_out\[115\]
+ net461 VSS VSS VDD VDD stage3_in_r\[115\] sky130_fd_sc_hd__dfrtp_1
Xstage3_in_r\[116\]$_DFF_PN0_ clknet_leaf_8_clk stage2_out\[116\]
+ net461 VSS VSS VDD VDD stage3_in_r\[116\] sky130_fd_sc_hd__dfrtp_1
Xstage3_in_r\[117\]$_DFF_PN0_ clknet_leaf_8_clk stage2_out\[117\]
+ net461 VSS VSS VDD VDD stage3_in_r\[117\] sky130_fd_sc_hd__dfrtp_1
Xstage3_in_r\[118\]$_DFF_PN0_ clknet_leaf_8_clk stage2_out\[118\]
+ net461 VSS VSS VDD VDD stage3_in_r\[118\] sky130_fd_sc_hd__dfrtp_1
Xstage3_in_r\[119\]$_DFF_PN0_ clknet_leaf_13_clk stage2_out\[119\]
+ net462 VSS VSS VDD VDD stage3_in_r\[119\] sky130_fd_sc_hd__dfrtp_1
Xstage3_in_r\[11\]$_DFF_PN0_ clknet_leaf_9_clk stage2_out\[11\]
+ net463 VSS VSS VDD VDD stage3_in_r\[11\] sky130_fd_sc_hd__dfrtp_1
Xstage3_in_r\[120\]$_DFF_PN0_ clknet_leaf_13_clk stage2_out\[120\]
+ net462 VSS VSS VDD VDD stage3_in_r\[120\] sky130_fd_sc_hd__dfrtp_1
Xstage3_in_r\[121\]$_DFF_PN0_ clknet_leaf_13_clk stage2_out\[121\]
+ net462 VSS VSS VDD VDD stage3_in_r\[121\] sky130_fd_sc_hd__dfrtp_1
Xstage3_in_r\[122\]$_DFF_PN0_ clknet_leaf_19_clk stage2_out\[122\]
+ net462 VSS VSS VDD VDD stage3_in_r\[122\] sky130_fd_sc_hd__dfrtp_1
Xstage3_in_r\[123\]$_DFF_PN0_ clknet_leaf_24_clk stage2_out\[123\]
+ net462 VSS VSS VDD VDD stage3_in_r\[123\] sky130_fd_sc_hd__dfrtp_1
Xstage3_in_r\[124\]$_DFF_PN0_ clknet_leaf_24_clk stage2_out\[124\]
+ net462 VSS VSS VDD VDD stage3_in_r\[124\] sky130_fd_sc_hd__dfrtp_1
Xstage3_in_r\[125\]$_DFF_PN0_ clknet_leaf_24_clk stage2_out\[125\]
+ net462 VSS VSS VDD VDD stage3_in_r\[125\] sky130_fd_sc_hd__dfrtp_1
Xstage3_in_r\[126\]$_DFF_PN0_ clknet_leaf_24_clk stage2_out\[126\]
+ net462 VSS VSS VDD VDD stage3_in_r\[126\] sky130_fd_sc_hd__dfrtp_1
Xstage3_in_r\[127\]$_DFF_PN0_ clknet_leaf_24_clk stage2_out\[127\]
+ net462 VSS VSS VDD VDD stage3_in_r\[127\] sky130_fd_sc_hd__dfrtp_1
Xstage3_in_r\[128\]$_DFF_PN0_ clknet_leaf_51_clk stage2_out\[128\]
+ net466 VSS VSS VDD VDD stage3_in_r\[128\] sky130_fd_sc_hd__dfrtp_1
Xstage3_in_r\[129\]$_DFF_PN0_ clknet_leaf_51_clk stage2_in_r\[146\]
+ net466 VSS VSS VDD VDD stage3_in_r\[129\] sky130_fd_sc_hd__dfrtp_1
Xstage3_in_r\[12\]$_DFF_PN0_ clknet_leaf_10_clk stage2_out\[12\]
+ net463 VSS VSS VDD VDD stage3_in_r\[12\] sky130_fd_sc_hd__dfrtp_1
Xstage3_in_r\[130\]$_DFF_PN0_ clknet_leaf_48_clk stage2_out\[130\]
+ net466 VSS VSS VDD VDD stage3_in_r\[130\] sky130_fd_sc_hd__dfrtp_1
Xstage3_in_r\[131\]$_DFF_PN0_ clknet_leaf_48_clk stage2_out\[131\]
+ net466 VSS VSS VDD VDD stage3_in_r\[131\] sky130_fd_sc_hd__dfrtp_1
Xstage3_in_r\[132\]$_DFF_PN0_ clknet_leaf_48_clk stage2_out\[132\]
+ net466 VSS VSS VDD VDD stage3_in_r\[132\] sky130_fd_sc_hd__dfrtp_1
Xstage3_in_r\[133\]$_DFF_PN0_ clknet_leaf_48_clk stage2_out\[133\]
+ net466 VSS VSS VDD VDD stage3_in_r\[133\] sky130_fd_sc_hd__dfrtp_1
Xstage3_in_r\[134\]$_DFF_PN0_ clknet_leaf_48_clk stage2_out\[134\]
+ net466 VSS VSS VDD VDD stage3_in_r\[134\] sky130_fd_sc_hd__dfrtp_1
Xstage3_in_r\[135\]$_DFF_PN0_ clknet_leaf_46_clk stage2_out\[135\]
+ net161 VSS VSS VDD VDD stage3_in_r\[135\] sky130_fd_sc_hd__dfrtp_1
Xstage3_in_r\[136\]$_DFF_PN0_ clknet_leaf_46_clk stage2_out\[136\]
+ net466 VSS VSS VDD VDD stage3_in_r\[136\] sky130_fd_sc_hd__dfrtp_1
Xstage3_in_r\[137\]$_DFF_PN0_ clknet_leaf_44_clk stage2_out\[137\]
+ net161 VSS VSS VDD VDD stage3_in_r\[137\] sky130_fd_sc_hd__dfrtp_1
Xstage3_in_r\[138\]$_DFF_PN0_ clknet_leaf_45_clk stage2_out\[138\]
+ net161 VSS VSS VDD VDD stage3_in_r\[138\] sky130_fd_sc_hd__dfrtp_1
Xstage3_in_r\[139\]$_DFF_PN0_ clknet_leaf_45_clk stage2_out\[139\]
+ net161 VSS VSS VDD VDD stage3_in_r\[139\] sky130_fd_sc_hd__dfrtp_1
Xstage3_in_r\[13\]$_DFF_PN0_ clknet_leaf_9_clk stage2_out\[13\]
+ net463 VSS VSS VDD VDD stage3_in_r\[13\] sky130_fd_sc_hd__dfrtp_1
Xstage3_in_r\[140\]$_DFF_PN0_ clknet_leaf_45_clk stage2_out\[140\]
+ net161 VSS VSS VDD VDD stage3_in_r\[140\] sky130_fd_sc_hd__dfrtp_1
Xstage3_in_r\[141\]$_DFF_PN0_ clknet_leaf_43_clk stage2_out\[141\]
+ net161 VSS VSS VDD VDD stage3_in_r\[141\] sky130_fd_sc_hd__dfrtp_1
Xstage3_in_r\[142\]$_DFF_PN0_ clknet_leaf_42_clk stage2_out\[142\]
+ net161 VSS VSS VDD VDD stage3_in_r\[142\] sky130_fd_sc_hd__dfrtp_1
Xstage3_in_r\[143\]$_DFF_PN0_ clknet_leaf_42_clk stage2_out\[143\]
+ net161 VSS VSS VDD VDD stage3_in_r\[143\] sky130_fd_sc_hd__dfrtp_1
Xstage3_in_r\[14\]$_DFF_PN0_ clknet_leaf_9_clk stage2_out\[14\]
+ net463 VSS VSS VDD VDD stage3_in_r\[14\] sky130_fd_sc_hd__dfrtp_1
Xstage3_in_r\[15\]$_DFF_PN0_ clknet_leaf_54_clk stage2_out\[15\]
+ net465 VSS VSS VDD VDD stage3_in_r\[15\] sky130_fd_sc_hd__dfrtp_1
Xstage3_in_r\[177\]$_DFF_PN0_ clknet_leaf_56_clk stage2_out\[177\]
+ net464 VSS VSS VDD VDD stage3_in_r\[177\] sky130_fd_sc_hd__dfrtp_1
Xstage3_in_r\[178\]$_DFF_PN0_ clknet_leaf_56_clk stage2_out\[178\]
+ net464 VSS VSS VDD VDD stage3_in_r\[178\] sky130_fd_sc_hd__dfrtp_1
Xstage3_in_r\[179\]$_DFF_PN0_ clknet_leaf_56_clk stage2_out\[179\]
+ net464 VSS VSS VDD VDD stage3_in_r\[179\] sky130_fd_sc_hd__dfrtp_1
Xstage3_in_r\[180\]$_DFF_PN0_ clknet_leaf_1_clk stage2_out\[180\]
+ net465 VSS VSS VDD VDD stage3_in_r\[180\] sky130_fd_sc_hd__dfrtp_1
Xstage3_in_r\[181\]$_DFF_PN0_ clknet_leaf_1_clk stage2_out\[181\]
+ net465 VSS VSS VDD VDD stage3_in_r\[181\] sky130_fd_sc_hd__dfrtp_1
Xstage3_in_r\[182\]$_DFF_PN0_ clknet_leaf_54_clk stage2_out\[182\]
+ net465 VSS VSS VDD VDD stage3_in_r\[182\] sky130_fd_sc_hd__dfrtp_1
Xstage3_in_r\[183\]$_DFF_PN0_ clknet_leaf_1_clk stage2_out\[183\]
+ net463 VSS VSS VDD VDD stage3_in_r\[183\] sky130_fd_sc_hd__dfrtp_1
Xstage3_in_r\[184\]$_DFF_PN0_ clknet_leaf_54_clk stage2_out\[184\]
+ net465 VSS VSS VDD VDD stage3_in_r\[184\] sky130_fd_sc_hd__dfrtp_1
Xstage3_in_r\[185\]$_DFF_PN0_ clknet_leaf_7_clk stage2_out\[185\]
+ net463 VSS VSS VDD VDD stage3_in_r\[185\] sky130_fd_sc_hd__dfrtp_1
Xstage3_in_r\[186\]$_DFF_PN0_ clknet_leaf_12_clk stage2_out\[186\]
+ net462 VSS VSS VDD VDD stage3_in_r\[186\] sky130_fd_sc_hd__dfrtp_1
Xstage3_in_r\[187\]$_DFF_PN0_ clknet_leaf_26_clk stage2_out\[187\]
+ net467 VSS VSS VDD VDD stage3_in_r\[187\] sky130_fd_sc_hd__dfrtp_1
Xstage3_in_r\[188\]$_DFF_PN0_ clknet_leaf_26_clk stage2_out\[188\]
+ net467 VSS VSS VDD VDD stage3_in_r\[188\] sky130_fd_sc_hd__dfrtp_1
Xstage3_in_r\[189\]$_DFF_PN0_ clknet_leaf_26_clk stage2_out\[189\]
+ net467 VSS VSS VDD VDD stage3_in_r\[189\] sky130_fd_sc_hd__dfrtp_1
Xstage3_in_r\[190\]$_DFF_PN0_ clknet_leaf_26_clk stage2_out\[190\]
+ net467 VSS VSS VDD VDD stage3_in_r\[190\] sky130_fd_sc_hd__dfrtp_1
Xstage3_in_r\[191\]$_DFF_PN0_ clknet_leaf_28_clk stage2_out\[191\]
+ net467 VSS VSS VDD VDD stage3_in_r\[191\] sky130_fd_sc_hd__dfrtp_1
Xstage3_in_r\[192\]$_DFF_PN0_ clknet_leaf_49_clk stage2_out\[192\]
+ net466 VSS VSS VDD VDD stage3_in_r\[192\] sky130_fd_sc_hd__dfrtp_1
Xstage3_in_r\[193\]$_DFF_PN0_ clknet_leaf_51_clk stage2_out\[193\]
+ net466 VSS VSS VDD VDD stage3_in_r\[193\] sky130_fd_sc_hd__dfrtp_1
Xstage3_in_r\[194\]$_DFF_PN0_ clknet_leaf_49_clk stage2_out\[194\]
+ net466 VSS VSS VDD VDD stage3_in_r\[194\] sky130_fd_sc_hd__dfrtp_1
Xstage3_in_r\[195\]$_DFF_PN0_ clknet_leaf_49_clk stage2_out\[195\]
+ net466 VSS VSS VDD VDD stage3_in_r\[195\] sky130_fd_sc_hd__dfrtp_1
Xstage3_in_r\[196\]$_DFF_PN0_ clknet_leaf_49_clk stage2_out\[196\]
+ net466 VSS VSS VDD VDD stage3_in_r\[196\] sky130_fd_sc_hd__dfrtp_1
Xstage3_in_r\[197\]$_DFF_PN0_ clknet_leaf_49_clk stage2_out\[197\]
+ net466 VSS VSS VDD VDD stage3_in_r\[197\] sky130_fd_sc_hd__dfrtp_1
Xstage3_in_r\[198\]$_DFF_PN0_ clknet_leaf_49_clk stage2_out\[198\]
+ net466 VSS VSS VDD VDD stage3_in_r\[198\] sky130_fd_sc_hd__dfrtp_1
Xstage3_in_r\[199\]$_DFF_PN0_ clknet_leaf_46_clk stage2_out\[199\]
+ net161 VSS VSS VDD VDD stage3_in_r\[199\] sky130_fd_sc_hd__dfrtp_1
Xstage3_in_r\[1\]$_DFF_PN0_ clknet_leaf_10_clk stage2_in_r\[18\]
+ net463 VSS VSS VDD VDD stage3_in_r\[1\] sky130_fd_sc_hd__dfrtp_1
Xstage3_in_r\[200\]$_DFF_PN0_ clknet_leaf_45_clk stage2_out\[200\]
+ net161 VSS VSS VDD VDD stage3_in_r\[200\] sky130_fd_sc_hd__dfrtp_1
Xstage3_in_r\[201\]$_DFF_PN0_ clknet_leaf_45_clk stage2_out\[201\]
+ net161 VSS VSS VDD VDD stage3_in_r\[201\] sky130_fd_sc_hd__dfrtp_1
Xstage3_in_r\[202\]$_DFF_PN0_ clknet_leaf_44_clk stage2_out\[202\]
+ net161 VSS VSS VDD VDD stage3_in_r\[202\] sky130_fd_sc_hd__dfrtp_1
Xstage3_in_r\[203\]$_DFF_PN0_ clknet_leaf_45_clk stage2_out\[203\]
+ net161 VSS VSS VDD VDD stage3_in_r\[203\] sky130_fd_sc_hd__dfrtp_1
Xstage3_in_r\[204\]$_DFF_PN0_ clknet_leaf_45_clk stage2_out\[204\]
+ net161 VSS VSS VDD VDD stage3_in_r\[204\] sky130_fd_sc_hd__dfrtp_1
Xstage3_in_r\[205\]$_DFF_PN0_ clknet_leaf_43_clk stage2_out\[205\]
+ net161 VSS VSS VDD VDD stage3_in_r\[205\] sky130_fd_sc_hd__dfrtp_1
Xstage3_in_r\[207\]$_DFF_PN0_ clknet_leaf_42_clk stage2_out\[206\]
+ net161 VSS VSS VDD VDD stage3_in_r\[206\] sky130_fd_sc_hd__dfrtp_1
Xstage3_in_r\[208\]$_DFF_PN0_ clknet_leaf_50_clk stage2_in_r\[209\]
+ net161 VSS VSS VDD VDD stage3_in_r\[144\] sky130_fd_sc_hd__dfrtp_1
Xstage3_in_r\[209\]$_DFF_PN0_ clknet_leaf_40_clk stage2_in_r\[210\]
+ net161 VSS VSS VDD VDD stage3_in_r\[145\] sky130_fd_sc_hd__dfrtp_1
Xstage3_in_r\[210\]$_DFF_PN0_ clknet_leaf_45_clk stage2_in_r\[211\]
+ net161 VSS VSS VDD VDD stage3_in_r\[146\] sky130_fd_sc_hd__dfrtp_1
Xstage3_in_r\[211\]$_DFF_PN0_ clknet_leaf_50_clk stage2_in_r\[212\]
+ net161 VSS VSS VDD VDD stage3_in_r\[147\] sky130_fd_sc_hd__dfrtp_1
Xstage3_in_r\[212\]$_DFF_PN0_ clknet_leaf_50_clk stage2_in_r\[213\]
+ net161 VSS VSS VDD VDD stage3_in_r\[148\] sky130_fd_sc_hd__dfrtp_1
Xstage3_in_r\[213\]$_DFF_PN0_ clknet_leaf_50_clk stage2_in_r\[214\]
+ net161 VSS VSS VDD VDD stage3_in_r\[149\] sky130_fd_sc_hd__dfrtp_1
Xstage3_in_r\[214\]$_DFF_PN0_ clknet_leaf_50_clk stage2_in_r\[215\]
+ net161 VSS VSS VDD VDD stage3_in_r\[150\] sky130_fd_sc_hd__dfrtp_1
Xstage3_in_r\[215\]$_DFF_PN0_ clknet_leaf_50_clk stage2_in_r\[216\]
+ net161 VSS VSS VDD VDD stage3_in_r\[151\] sky130_fd_sc_hd__dfrtp_1
Xstage3_in_r\[216\]$_DFF_PN0_ clknet_leaf_50_clk stage2_in_r\[217\]
+ net161 VSS VSS VDD VDD stage3_in_r\[152\] sky130_fd_sc_hd__dfrtp_1
Xstage3_in_r\[217\]$_DFF_PN0_ clknet_leaf_37_clk stage2_in_r\[218\]
+ net161 VSS VSS VDD VDD stage3_in_r\[153\] sky130_fd_sc_hd__dfrtp_1
Xstage3_in_r\[218\]$_DFF_PN0_ clknet_leaf_33_clk stage2_in_r\[219\]
+ net468 VSS VSS VDD VDD stage3_in_r\[154\] sky130_fd_sc_hd__dfrtp_1
Xstage3_in_r\[219\]$_DFF_PN0_ clknet_leaf_33_clk stage2_in_r\[220\]
+ net468 VSS VSS VDD VDD stage3_in_r\[155\] sky130_fd_sc_hd__dfrtp_1
Xstage3_in_r\[220\]$_DFF_PN0_ clknet_leaf_32_clk stage2_in_r\[221\]
+ net468 VSS VSS VDD VDD stage3_in_r\[156\] sky130_fd_sc_hd__dfrtp_1
Xstage3_in_r\[221\]$_DFF_PN0_ clknet_leaf_32_clk stage2_in_r\[222\]
+ net468 VSS VSS VDD VDD stage3_in_r\[157\] sky130_fd_sc_hd__dfrtp_1
Xstage3_in_r\[223\]$_DFF_PN0_ clknet_leaf_32_clk stage2_in_r\[223\]
+ net468 VSS VSS VDD VDD stage3_in_r\[158\] sky130_fd_sc_hd__dfrtp_1
Xstage3_in_r\[240\]$_DFF_PN0_ clknet_leaf_1_clk stage2_out\[240\]
+ net465 VSS VSS VDD VDD stage3_in_r\[240\] sky130_fd_sc_hd__dfrtp_1
Xstage3_in_r\[241\]$_DFF_PN0_ clknet_leaf_3_clk stage2_out\[241\]
+ net460 VSS VSS VDD VDD stage3_in_r\[241\] sky130_fd_sc_hd__dfrtp_1
Xstage3_in_r\[242\]$_DFF_PN0_ clknet_leaf_1_clk stage2_out\[242\]
+ net465 VSS VSS VDD VDD stage3_in_r\[242\] sky130_fd_sc_hd__dfrtp_1
Xstage3_in_r\[243\]$_DFF_PN0_ clknet_leaf_3_clk stage2_out\[243\]
+ net465 VSS VSS VDD VDD stage3_in_r\[243\] sky130_fd_sc_hd__dfrtp_1
Xstage3_in_r\[244\]$_DFF_PN0_ clknet_leaf_3_clk stage2_out\[244\]
+ net465 VSS VSS VDD VDD stage3_in_r\[244\] sky130_fd_sc_hd__dfrtp_1
Xstage3_in_r\[245\]$_DFF_PN0_ clknet_leaf_1_clk stage2_out\[245\]
+ net465 VSS VSS VDD VDD stage3_in_r\[245\] sky130_fd_sc_hd__dfrtp_1
Xstage3_in_r\[246\]$_DFF_PN0_ clknet_leaf_2_clk stage2_out\[246\]
+ net465 VSS VSS VDD VDD stage3_in_r\[246\] sky130_fd_sc_hd__dfrtp_1
Xstage3_in_r\[247\]$_DFF_PN0_ clknet_leaf_2_clk stage2_out\[247\]
+ net463 VSS VSS VDD VDD stage3_in_r\[247\] sky130_fd_sc_hd__dfrtp_1
Xstage3_in_r\[248\]$_DFF_PN0_ clknet_leaf_7_clk stage2_out\[248\]
+ net463 VSS VSS VDD VDD stage3_in_r\[248\] sky130_fd_sc_hd__dfrtp_1
Xstage3_in_r\[249\]$_DFF_PN0_ clknet_leaf_13_clk stage2_out\[249\]
+ net463 VSS VSS VDD VDD stage3_in_r\[249\] sky130_fd_sc_hd__dfrtp_1
Xstage3_in_r\[250\]$_DFF_PN0_ clknet_leaf_31_clk stage2_out\[250\]
+ net462 VSS VSS VDD VDD stage3_in_r\[250\] sky130_fd_sc_hd__dfrtp_1
Xstage3_in_r\[251\]$_DFF_PN0_ clknet_leaf_30_clk stage2_out\[251\]
+ net462 VSS VSS VDD VDD stage3_in_r\[251\] sky130_fd_sc_hd__dfrtp_1
Xstage3_in_r\[252\]$_DFF_PN0_ clknet_leaf_25_clk stage2_out\[252\]
+ net462 VSS VSS VDD VDD stage3_in_r\[252\] sky130_fd_sc_hd__dfrtp_1
Xstage3_in_r\[253\]$_DFF_PN0_ clknet_leaf_25_clk stage2_out\[253\]
+ net462 VSS VSS VDD VDD stage3_in_r\[253\] sky130_fd_sc_hd__dfrtp_1
Xstage3_in_r\[254\]$_DFF_PN0_ clknet_leaf_25_clk stage2_out\[254\]
+ net462 VSS VSS VDD VDD stage3_in_r\[254\] sky130_fd_sc_hd__dfrtp_1
Xstage3_in_r\[255\]$_DFF_PN0_ clknet_leaf_26_clk stage2_out\[255\]
+ net467 VSS VSS VDD VDD stage3_in_r\[255\] sky130_fd_sc_hd__dfrtp_1
Xstage3_in_r\[2\]$_DFF_PN0_ clknet_leaf_10_clk stage2_out\[2\]
+ net463 VSS VSS VDD VDD stage3_in_r\[2\] sky130_fd_sc_hd__dfrtp_1
Xstage3_in_r\[3\]$_DFF_PN0_ clknet_leaf_9_clk stage2_out\[3\]
+ net463 VSS VSS VDD VDD stage3_in_r\[3\] sky130_fd_sc_hd__dfrtp_1
Xstage3_in_r\[48\]$_DFF_PN0_ clknet_leaf_17_clk stage2_out\[48\]
+ net461 VSS VSS VDD VDD stage3_in_r\[48\] sky130_fd_sc_hd__dfrtp_1
Xstage3_in_r\[49\]$_DFF_PN0_ clknet_leaf_14_clk stage2_out\[49\]
+ net460 VSS VSS VDD VDD stage3_in_r\[49\] sky130_fd_sc_hd__dfrtp_1
Xstage3_in_r\[4\]$_DFF_PN0_ clknet_leaf_9_clk stage2_out\[4\]
+ net463 VSS VSS VDD VDD stage3_in_r\[4\] sky130_fd_sc_hd__dfrtp_1
Xstage3_in_r\[50\]$_DFF_PN0_ clknet_leaf_17_clk stage2_out\[50\]
+ net461 VSS VSS VDD VDD stage3_in_r\[50\] sky130_fd_sc_hd__dfrtp_1
Xstage3_in_r\[51\]$_DFF_PN0_ clknet_leaf_18_clk stage2_out\[51\]
+ net461 VSS VSS VDD VDD stage3_in_r\[51\] sky130_fd_sc_hd__dfrtp_1
Xstage3_in_r\[52\]$_DFF_PN0_ clknet_leaf_17_clk stage2_out\[52\]
+ net461 VSS VSS VDD VDD stage3_in_r\[52\] sky130_fd_sc_hd__dfrtp_1
Xstage3_in_r\[53\]$_DFF_PN0_ clknet_leaf_18_clk stage2_out\[53\]
+ net461 VSS VSS VDD VDD stage3_in_r\[53\] sky130_fd_sc_hd__dfrtp_1
Xstage3_in_r\[54\]$_DFF_PN0_ clknet_leaf_18_clk stage2_out\[54\]
+ net461 VSS VSS VDD VDD stage3_in_r\[54\] sky130_fd_sc_hd__dfrtp_1
Xstage3_in_r\[55\]$_DFF_PN0_ clknet_leaf_18_clk stage2_out\[55\]
+ net461 VSS VSS VDD VDD stage3_in_r\[55\] sky130_fd_sc_hd__dfrtp_1
Xstage3_in_r\[56\]$_DFF_PN0_ clknet_leaf_19_clk stage2_out\[56\]
+ net461 VSS VSS VDD VDD stage3_in_r\[56\] sky130_fd_sc_hd__dfrtp_1
Xstage3_in_r\[57\]$_DFF_PN0_ clknet_leaf_19_clk stage2_out\[57\]
+ net461 VSS VSS VDD VDD stage3_in_r\[57\] sky130_fd_sc_hd__dfrtp_1
Xstage3_in_r\[58\]$_DFF_PN0_ clknet_leaf_19_clk stage2_out\[58\]
+ net461 VSS VSS VDD VDD stage3_in_r\[58\] sky130_fd_sc_hd__dfrtp_1
Xstage3_in_r\[59\]$_DFF_PN0_ clknet_leaf_19_clk stage2_out\[59\]
+ net461 VSS VSS VDD VDD stage3_in_r\[59\] sky130_fd_sc_hd__dfrtp_1
Xstage3_in_r\[5\]$_DFF_PN0_ clknet_leaf_9_clk stage2_out\[5\]
+ net463 VSS VSS VDD VDD stage3_in_r\[5\] sky130_fd_sc_hd__dfrtp_1
Xstage3_in_r\[60\]$_DFF_PN0_ clknet_leaf_19_clk stage2_out\[60\]
+ net461 VSS VSS VDD VDD stage3_in_r\[60\] sky130_fd_sc_hd__dfrtp_1
Xstage3_in_r\[61\]$_DFF_PN0_ clknet_leaf_19_clk stage2_out\[61\]
+ net461 VSS VSS VDD VDD stage3_in_r\[61\] sky130_fd_sc_hd__dfrtp_1
Xstage3_in_r\[62\]$_DFF_PN0_ clknet_leaf_20_clk stage2_out\[62\]
+ net461 VSS VSS VDD VDD stage3_in_r\[62\] sky130_fd_sc_hd__dfrtp_1
Xstage3_in_r\[63\]$_DFF_PN0_ clknet_leaf_20_clk stage2_out\[63\]
+ net461 VSS VSS VDD VDD stage3_in_r\[63\] sky130_fd_sc_hd__dfrtp_1
Xstage3_in_r\[64\]$_DFF_PN0_ clknet_leaf_10_clk stage2_out\[64\]
+ net463 VSS VSS VDD VDD stage3_in_r\[64\] sky130_fd_sc_hd__dfrtp_2
Xstage3_in_r\[65\]$_DFF_PN0_ clknet_leaf_10_clk stage2_out\[65\]
+ net463 VSS VSS VDD VDD stage3_in_r\[65\] sky130_fd_sc_hd__dfrtp_2
Xstage3_in_r\[66\]$_DFF_PN0_ clknet_leaf_10_clk stage2_out\[66\]
+ net463 VSS VSS VDD VDD stage3_in_r\[66\] sky130_fd_sc_hd__dfrtp_1
Xstage3_in_r\[67\]$_DFF_PN0_ clknet_leaf_10_clk stage2_out\[67\]
+ net463 VSS VSS VDD VDD stage3_in_r\[67\] sky130_fd_sc_hd__dfrtp_1
Xstage3_in_r\[68\]$_DFF_PN0_ clknet_leaf_10_clk stage2_out\[68\]
+ net463 VSS VSS VDD VDD stage3_in_r\[68\] sky130_fd_sc_hd__dfrtp_1
Xstage3_in_r\[69\]$_DFF_PN0_ clknet_leaf_11_clk stage2_out\[69\]
+ net463 VSS VSS VDD VDD stage3_in_r\[69\] sky130_fd_sc_hd__dfrtp_1
Xstage3_in_r\[6\]$_DFF_PN0_ clknet_leaf_9_clk stage2_out\[6\]
+ net463 VSS VSS VDD VDD stage3_in_r\[6\] sky130_fd_sc_hd__dfrtp_1
Xstage3_in_r\[70\]$_DFF_PN0_ clknet_leaf_36_clk stage2_out\[70\]
+ net161 VSS VSS VDD VDD stage3_in_r\[70\] sky130_fd_sc_hd__dfrtp_1
Xstage3_in_r\[71\]$_DFF_PN0_ clknet_leaf_36_clk stage2_out\[71\]
+ net161 VSS VSS VDD VDD stage3_in_r\[71\] sky130_fd_sc_hd__dfrtp_2
Xstage3_in_r\[72\]$_DFF_PN0_ clknet_leaf_37_clk stage2_out\[72\]
+ net161 VSS VSS VDD VDD stage3_in_r\[72\] sky130_fd_sc_hd__dfrtp_2
Xstage3_in_r\[73\]$_DFF_PN0_ clknet_leaf_36_clk stage2_out\[73\]
+ net161 VSS VSS VDD VDD stage3_in_r\[73\] sky130_fd_sc_hd__dfrtp_1
Xstage3_in_r\[74\]$_DFF_PN0_ clknet_leaf_36_clk stage2_out\[74\]
+ net161 VSS VSS VDD VDD stage3_in_r\[74\] sky130_fd_sc_hd__dfrtp_1
Xstage3_in_r\[75\]$_DFF_PN0_ clknet_leaf_36_clk stage2_out\[75\]
+ net161 VSS VSS VDD VDD stage3_in_r\[75\] sky130_fd_sc_hd__dfrtp_1
Xstage3_in_r\[76\]$_DFF_PN0_ clknet_leaf_36_clk stage2_out\[76\]
+ net161 VSS VSS VDD VDD stage3_in_r\[76\] sky130_fd_sc_hd__dfrtp_1
Xstage3_in_r\[77\]$_DFF_PN0_ clknet_leaf_36_clk stage2_out\[77\]
+ net161 VSS VSS VDD VDD stage3_in_r\[77\] sky130_fd_sc_hd__dfrtp_1
Xstage3_in_r\[79\]$_DFF_PN0_ clknet_leaf_36_clk stage2_out\[78\]
+ net161 VSS VSS VDD VDD stage3_in_r\[78\] sky130_fd_sc_hd__dfrtp_1
Xstage3_in_r\[7\]$_DFF_PN0_ clknet_leaf_9_clk stage2_out\[7\]
+ net463 VSS VSS VDD VDD stage3_in_r\[7\] sky130_fd_sc_hd__dfrtp_1
Xstage3_in_r\[80\]$_DFF_PN0_ clknet_leaf_11_clk stage2_in_r\[81\]
+ net463 VSS VSS VDD VDD stage3_in_r\[16\] sky130_fd_sc_hd__dfrtp_1
Xstage3_in_r\[81\]$_DFF_PN0_ clknet_leaf_11_clk stage2_in_r\[82\]
+ net463 VSS VSS VDD VDD stage3_in_r\[17\] sky130_fd_sc_hd__dfrtp_2
Xstage3_in_r\[82\]$_DFF_PN0_ clknet_leaf_11_clk stage2_in_r\[83\]
+ net463 VSS VSS VDD VDD stage3_in_r\[18\] sky130_fd_sc_hd__dfrtp_1
Xstage3_in_r\[83\]$_DFF_PN0_ clknet_leaf_11_clk stage2_in_r\[84\]
+ net463 VSS VSS VDD VDD stage3_in_r\[19\] sky130_fd_sc_hd__dfrtp_1
Xstage3_in_r\[84\]$_DFF_PN0_ clknet_leaf_31_clk stage2_in_r\[85\]
+ net463 VSS VSS VDD VDD stage3_in_r\[20\] sky130_fd_sc_hd__dfrtp_1
Xstage3_in_r\[85\]$_DFF_PN0_ clknet_leaf_31_clk stage2_in_r\[86\]
+ net462 VSS VSS VDD VDD stage3_in_r\[21\] sky130_fd_sc_hd__dfrtp_1
Xstage3_in_r\[86\]$_DFF_PN0_ clknet_leaf_31_clk stage2_in_r\[87\]
+ net463 VSS VSS VDD VDD stage3_in_r\[22\] sky130_fd_sc_hd__dfrtp_1
Xstage3_in_r\[87\]$_DFF_PN0_ clknet_leaf_30_clk stage2_in_r\[88\]
+ net462 VSS VSS VDD VDD stage3_in_r\[23\] sky130_fd_sc_hd__dfrtp_1
Xstage3_in_r\[88\]$_DFF_PN0_ clknet_leaf_30_clk stage2_in_r\[89\]
+ net463 VSS VSS VDD VDD stage3_in_r\[24\] sky130_fd_sc_hd__dfrtp_1
Xstage3_in_r\[89\]$_DFF_PN0_ clknet_leaf_30_clk stage2_in_r\[90\]
+ net462 VSS VSS VDD VDD stage3_in_r\[25\] sky130_fd_sc_hd__dfrtp_1
Xstage3_in_r\[8\]$_DFF_PN0_ clknet_leaf_9_clk stage2_out\[8\]
+ net463 VSS VSS VDD VDD stage3_in_r\[8\] sky130_fd_sc_hd__dfrtp_1
Xstage3_in_r\[90\]$_DFF_PN0_ clknet_leaf_30_clk stage2_in_r\[91\]
+ net462 VSS VSS VDD VDD stage3_in_r\[26\] sky130_fd_sc_hd__dfrtp_1
Xstage3_in_r\[91\]$_DFF_PN0_ clknet_leaf_30_clk stage2_in_r\[92\]
+ net462 VSS VSS VDD VDD stage3_in_r\[27\] sky130_fd_sc_hd__dfrtp_1
Xstage3_in_r\[92\]$_DFF_PN0_ clknet_leaf_29_clk stage2_in_r\[93\]
+ net467 VSS VSS VDD VDD stage3_in_r\[28\] sky130_fd_sc_hd__dfrtp_1
Xstage3_in_r\[93\]$_DFF_PN0_ clknet_leaf_28_clk stage2_in_r\[94\]
+ net467 VSS VSS VDD VDD stage3_in_r\[29\] sky130_fd_sc_hd__dfrtp_1
Xstage3_in_r\[95\]$_DFF_PN0_ clknet_leaf_29_clk stage2_in_r\[95\]
+ net467 VSS VSS VDD VDD stage3_in_r\[30\] sky130_fd_sc_hd__dfrtp_2
Xstage3_in_r\[9\]$_DFF_PN0_ clknet_leaf_9_clk stage2_out\[9\]
+ net463 VSS VSS VDD VDD stage3_in_r\[9\] sky130_fd_sc_hd__dfrtp_2
Xv1$_DFF_PN0_ clknet_leaf_57_clk net160 net464 VSS VSS VDD
+ VDD v1 sky130_fd_sc_hd__dfrtp_1
Xv2$_DFF_PN0_ clknet_leaf_57_clk v1 net464 VSS VSS VDD VDD
+ v2 sky130_fd_sc_hd__dfrtp_1
Xv3$_DFF_PN0_ clknet_leaf_56_clk v2 net464 VSS VSS VDD VDD
+ v3 sky130_fd_sc_hd__dfrtp_1
X_11138__1 VSS VSS VDD VDD _unconnected_0 out_flat[96] sky130_fd_sc_hd__conb_1
X_11139__2 VSS VSS VDD VDD _unconnected_1 out_flat[97] sky130_fd_sc_hd__conb_1
X_11140__3 VSS VSS VDD VDD _unconnected_2 out_flat[98] sky130_fd_sc_hd__conb_1
X_11141__4 VSS VSS VDD VDD _unconnected_3 out_flat[99] sky130_fd_sc_hd__conb_1
X_11142__5 VSS VSS VDD VDD _unconnected_4 out_flat[100] sky130_fd_sc_hd__conb_1
X_11143__6 VSS VSS VDD VDD _unconnected_5 out_flat[101] sky130_fd_sc_hd__conb_1
X_11144__7 VSS VSS VDD VDD _unconnected_6 out_flat[102] sky130_fd_sc_hd__conb_1
X_11145__8 VSS VSS VDD VDD _unconnected_7 out_flat[103] sky130_fd_sc_hd__conb_1
X_11146__9 VSS VSS VDD VDD _unconnected_8 out_flat[104] sky130_fd_sc_hd__conb_1
X_11147__10 VSS VSS VDD VDD _unconnected_9 out_flat[105] sky130_fd_sc_hd__conb_1
X_11148__11 VSS VSS VDD VDD _unconnected_10 out_flat[106]
+ sky130_fd_sc_hd__conb_1
X_11149__12 VSS VSS VDD VDD _unconnected_11 out_flat[107]
+ sky130_fd_sc_hd__conb_1
X_11150__13 VSS VSS VDD VDD _unconnected_12 out_flat[108]
+ sky130_fd_sc_hd__conb_1
X_11151__14 VSS VSS VDD VDD _unconnected_13 out_flat[109]
+ sky130_fd_sc_hd__conb_1
X_11152__15 VSS VSS VDD VDD _unconnected_14 out_flat[110]
+ sky130_fd_sc_hd__conb_1
X_11153__16 VSS VSS VDD VDD _unconnected_15 out_flat[111]
+ sky130_fd_sc_hd__conb_1
X_11156__17 VSS VSS VDD VDD _unconnected_16 out_flat[224]
+ sky130_fd_sc_hd__conb_1
X_11157__18 VSS VSS VDD VDD _unconnected_17 out_flat[225]
+ sky130_fd_sc_hd__conb_1
X_11158__19 VSS VSS VDD VDD _unconnected_18 out_flat[226]
+ sky130_fd_sc_hd__conb_1
X_11159__20 VSS VSS VDD VDD _unconnected_19 out_flat[227]
+ sky130_fd_sc_hd__conb_1
X_11160__21 VSS VSS VDD VDD _unconnected_20 out_flat[228]
+ sky130_fd_sc_hd__conb_1
X_11161__22 VSS VSS VDD VDD _unconnected_21 out_flat[229]
+ sky130_fd_sc_hd__conb_1
X_11162__23 VSS VSS VDD VDD _unconnected_22 out_flat[230]
+ sky130_fd_sc_hd__conb_1
X_11163__24 VSS VSS VDD VDD _unconnected_23 out_flat[231]
+ sky130_fd_sc_hd__conb_1
X_11164__25 VSS VSS VDD VDD _unconnected_24 out_flat[232]
+ sky130_fd_sc_hd__conb_1
X_11165__26 VSS VSS VDD VDD _unconnected_25 out_flat[233]
+ sky130_fd_sc_hd__conb_1
X_11166__27 VSS VSS VDD VDD _unconnected_26 out_flat[234]
+ sky130_fd_sc_hd__conb_1
X_11167__28 VSS VSS VDD VDD _unconnected_27 out_flat[235]
+ sky130_fd_sc_hd__conb_1
X_11168__29 VSS VSS VDD VDD _unconnected_28 out_flat[236]
+ sky130_fd_sc_hd__conb_1
X_11169__30 VSS VSS VDD VDD _unconnected_29 out_flat[237]
+ sky130_fd_sc_hd__conb_1
X_11170__31 VSS VSS VDD VDD _unconnected_30 out_flat[238]
+ sky130_fd_sc_hd__conb_1
X_11171__32 VSS VSS VDD VDD _unconnected_31 out_flat[239]
+ sky130_fd_sc_hd__conb_1
XTAP_TAPCELL_ROW_0_1 VSS VDD sky130_fd_sc_hd__tapvpwrvgnd_1
XTAP_TAPCELL_ROW_0_2 VSS VDD sky130_fd_sc_hd__tapvpwrvgnd_1
XTAP_TAPCELL_ROW_0_3 VSS VDD sky130_fd_sc_hd__tapvpwrvgnd_1
XTAP_TAPCELL_ROW_0_4 VSS VDD sky130_fd_sc_hd__tapvpwrvgnd_1
XTAP_TAPCELL_ROW_0_5 VSS VDD sky130_fd_sc_hd__tapvpwrvgnd_1
XTAP_TAPCELL_ROW_0_6 VSS VDD sky130_fd_sc_hd__tapvpwrvgnd_1
XTAP_TAPCELL_ROW_0_7 VSS VDD sky130_fd_sc_hd__tapvpwrvgnd_1
XTAP_TAPCELL_ROW_0_8 VSS VDD sky130_fd_sc_hd__tapvpwrvgnd_1
XTAP_TAPCELL_ROW_0_9 VSS VDD sky130_fd_sc_hd__tapvpwrvgnd_1
XTAP_TAPCELL_ROW_0_10 VSS VDD sky130_fd_sc_hd__tapvpwrvgnd_1
XTAP_TAPCELL_ROW_0_11 VSS VDD sky130_fd_sc_hd__tapvpwrvgnd_1
XTAP_TAPCELL_ROW_0_12 VSS VDD sky130_fd_sc_hd__tapvpwrvgnd_1
XTAP_TAPCELL_ROW_0_13 VSS VDD sky130_fd_sc_hd__tapvpwrvgnd_1
XTAP_TAPCELL_ROW_0_14 VSS VDD sky130_fd_sc_hd__tapvpwrvgnd_1
XTAP_TAPCELL_ROW_0_15 VSS VDD sky130_fd_sc_hd__tapvpwrvgnd_1
XTAP_TAPCELL_ROW_0_16 VSS VDD sky130_fd_sc_hd__tapvpwrvgnd_1
XTAP_TAPCELL_ROW_0_17 VSS VDD sky130_fd_sc_hd__tapvpwrvgnd_1
XTAP_TAPCELL_ROW_0_18 VSS VDD sky130_fd_sc_hd__tapvpwrvgnd_1
XTAP_TAPCELL_ROW_0_19 VSS VDD sky130_fd_sc_hd__tapvpwrvgnd_1
XTAP_TAPCELL_ROW_1_20 VSS VDD sky130_fd_sc_hd__tapvpwrvgnd_1
XTAP_TAPCELL_ROW_1_21 VSS VDD sky130_fd_sc_hd__tapvpwrvgnd_1
XTAP_TAPCELL_ROW_1_22 VSS VDD sky130_fd_sc_hd__tapvpwrvgnd_1
XTAP_TAPCELL_ROW_1_23 VSS VDD sky130_fd_sc_hd__tapvpwrvgnd_1
XTAP_TAPCELL_ROW_1_24 VSS VDD sky130_fd_sc_hd__tapvpwrvgnd_1
XTAP_TAPCELL_ROW_1_25 VSS VDD sky130_fd_sc_hd__tapvpwrvgnd_1
XTAP_TAPCELL_ROW_1_26 VSS VDD sky130_fd_sc_hd__tapvpwrvgnd_1
XTAP_TAPCELL_ROW_1_27 VSS VDD sky130_fd_sc_hd__tapvpwrvgnd_1
XTAP_TAPCELL_ROW_1_28 VSS VDD sky130_fd_sc_hd__tapvpwrvgnd_1
XTAP_TAPCELL_ROW_1_29 VSS VDD sky130_fd_sc_hd__tapvpwrvgnd_1
XTAP_TAPCELL_ROW_2_30 VSS VDD sky130_fd_sc_hd__tapvpwrvgnd_1
XTAP_TAPCELL_ROW_2_31 VSS VDD sky130_fd_sc_hd__tapvpwrvgnd_1
XTAP_TAPCELL_ROW_2_32 VSS VDD sky130_fd_sc_hd__tapvpwrvgnd_1
XTAP_TAPCELL_ROW_2_33 VSS VDD sky130_fd_sc_hd__tapvpwrvgnd_1
XTAP_TAPCELL_ROW_2_34 VSS VDD sky130_fd_sc_hd__tapvpwrvgnd_1
XTAP_TAPCELL_ROW_2_35 VSS VDD sky130_fd_sc_hd__tapvpwrvgnd_1
XTAP_TAPCELL_ROW_2_36 VSS VDD sky130_fd_sc_hd__tapvpwrvgnd_1
XTAP_TAPCELL_ROW_2_37 VSS VDD sky130_fd_sc_hd__tapvpwrvgnd_1
XTAP_TAPCELL_ROW_2_38 VSS VDD sky130_fd_sc_hd__tapvpwrvgnd_1
XTAP_TAPCELL_ROW_2_39 VSS VDD sky130_fd_sc_hd__tapvpwrvgnd_1
XTAP_TAPCELL_ROW_3_40 VSS VDD sky130_fd_sc_hd__tapvpwrvgnd_1
XTAP_TAPCELL_ROW_3_41 VSS VDD sky130_fd_sc_hd__tapvpwrvgnd_1
XTAP_TAPCELL_ROW_3_42 VSS VDD sky130_fd_sc_hd__tapvpwrvgnd_1
XTAP_TAPCELL_ROW_3_43 VSS VDD sky130_fd_sc_hd__tapvpwrvgnd_1
XTAP_TAPCELL_ROW_3_44 VSS VDD sky130_fd_sc_hd__tapvpwrvgnd_1
XTAP_TAPCELL_ROW_3_45 VSS VDD sky130_fd_sc_hd__tapvpwrvgnd_1
XTAP_TAPCELL_ROW_3_46 VSS VDD sky130_fd_sc_hd__tapvpwrvgnd_1
XTAP_TAPCELL_ROW_3_47 VSS VDD sky130_fd_sc_hd__tapvpwrvgnd_1
XTAP_TAPCELL_ROW_3_48 VSS VDD sky130_fd_sc_hd__tapvpwrvgnd_1
XTAP_TAPCELL_ROW_3_49 VSS VDD sky130_fd_sc_hd__tapvpwrvgnd_1
XTAP_TAPCELL_ROW_4_50 VSS VDD sky130_fd_sc_hd__tapvpwrvgnd_1
XTAP_TAPCELL_ROW_4_51 VSS VDD sky130_fd_sc_hd__tapvpwrvgnd_1
XTAP_TAPCELL_ROW_4_52 VSS VDD sky130_fd_sc_hd__tapvpwrvgnd_1
XTAP_TAPCELL_ROW_4_53 VSS VDD sky130_fd_sc_hd__tapvpwrvgnd_1
XTAP_TAPCELL_ROW_4_54 VSS VDD sky130_fd_sc_hd__tapvpwrvgnd_1
XTAP_TAPCELL_ROW_4_55 VSS VDD sky130_fd_sc_hd__tapvpwrvgnd_1
XTAP_TAPCELL_ROW_4_56 VSS VDD sky130_fd_sc_hd__tapvpwrvgnd_1
XTAP_TAPCELL_ROW_4_57 VSS VDD sky130_fd_sc_hd__tapvpwrvgnd_1
XTAP_TAPCELL_ROW_4_58 VSS VDD sky130_fd_sc_hd__tapvpwrvgnd_1
XTAP_TAPCELL_ROW_4_59 VSS VDD sky130_fd_sc_hd__tapvpwrvgnd_1
XTAP_TAPCELL_ROW_5_60 VSS VDD sky130_fd_sc_hd__tapvpwrvgnd_1
XTAP_TAPCELL_ROW_5_61 VSS VDD sky130_fd_sc_hd__tapvpwrvgnd_1
XTAP_TAPCELL_ROW_5_62 VSS VDD sky130_fd_sc_hd__tapvpwrvgnd_1
XTAP_TAPCELL_ROW_5_63 VSS VDD sky130_fd_sc_hd__tapvpwrvgnd_1
XTAP_TAPCELL_ROW_5_64 VSS VDD sky130_fd_sc_hd__tapvpwrvgnd_1
XTAP_TAPCELL_ROW_5_65 VSS VDD sky130_fd_sc_hd__tapvpwrvgnd_1
XTAP_TAPCELL_ROW_5_66 VSS VDD sky130_fd_sc_hd__tapvpwrvgnd_1
XTAP_TAPCELL_ROW_5_67 VSS VDD sky130_fd_sc_hd__tapvpwrvgnd_1
XTAP_TAPCELL_ROW_5_68 VSS VDD sky130_fd_sc_hd__tapvpwrvgnd_1
XTAP_TAPCELL_ROW_5_69 VSS VDD sky130_fd_sc_hd__tapvpwrvgnd_1
XTAP_TAPCELL_ROW_6_70 VSS VDD sky130_fd_sc_hd__tapvpwrvgnd_1
XTAP_TAPCELL_ROW_6_71 VSS VDD sky130_fd_sc_hd__tapvpwrvgnd_1
XTAP_TAPCELL_ROW_6_72 VSS VDD sky130_fd_sc_hd__tapvpwrvgnd_1
XTAP_TAPCELL_ROW_6_73 VSS VDD sky130_fd_sc_hd__tapvpwrvgnd_1
XTAP_TAPCELL_ROW_6_74 VSS VDD sky130_fd_sc_hd__tapvpwrvgnd_1
XTAP_TAPCELL_ROW_6_75 VSS VDD sky130_fd_sc_hd__tapvpwrvgnd_1
XTAP_TAPCELL_ROW_6_76 VSS VDD sky130_fd_sc_hd__tapvpwrvgnd_1
XTAP_TAPCELL_ROW_6_77 VSS VDD sky130_fd_sc_hd__tapvpwrvgnd_1
XTAP_TAPCELL_ROW_6_78 VSS VDD sky130_fd_sc_hd__tapvpwrvgnd_1
XTAP_TAPCELL_ROW_6_79 VSS VDD sky130_fd_sc_hd__tapvpwrvgnd_1
XTAP_TAPCELL_ROW_7_80 VSS VDD sky130_fd_sc_hd__tapvpwrvgnd_1
XTAP_TAPCELL_ROW_7_81 VSS VDD sky130_fd_sc_hd__tapvpwrvgnd_1
XTAP_TAPCELL_ROW_7_82 VSS VDD sky130_fd_sc_hd__tapvpwrvgnd_1
XTAP_TAPCELL_ROW_7_83 VSS VDD sky130_fd_sc_hd__tapvpwrvgnd_1
XTAP_TAPCELL_ROW_7_84 VSS VDD sky130_fd_sc_hd__tapvpwrvgnd_1
XTAP_TAPCELL_ROW_7_85 VSS VDD sky130_fd_sc_hd__tapvpwrvgnd_1
XTAP_TAPCELL_ROW_7_86 VSS VDD sky130_fd_sc_hd__tapvpwrvgnd_1
XTAP_TAPCELL_ROW_7_87 VSS VDD sky130_fd_sc_hd__tapvpwrvgnd_1
XTAP_TAPCELL_ROW_7_88 VSS VDD sky130_fd_sc_hd__tapvpwrvgnd_1
XTAP_TAPCELL_ROW_7_89 VSS VDD sky130_fd_sc_hd__tapvpwrvgnd_1
XTAP_TAPCELL_ROW_8_90 VSS VDD sky130_fd_sc_hd__tapvpwrvgnd_1
XTAP_TAPCELL_ROW_8_91 VSS VDD sky130_fd_sc_hd__tapvpwrvgnd_1
XTAP_TAPCELL_ROW_8_92 VSS VDD sky130_fd_sc_hd__tapvpwrvgnd_1
XTAP_TAPCELL_ROW_8_93 VSS VDD sky130_fd_sc_hd__tapvpwrvgnd_1
XTAP_TAPCELL_ROW_8_94 VSS VDD sky130_fd_sc_hd__tapvpwrvgnd_1
XTAP_TAPCELL_ROW_8_95 VSS VDD sky130_fd_sc_hd__tapvpwrvgnd_1
XTAP_TAPCELL_ROW_8_96 VSS VDD sky130_fd_sc_hd__tapvpwrvgnd_1
XTAP_TAPCELL_ROW_8_97 VSS VDD sky130_fd_sc_hd__tapvpwrvgnd_1
XTAP_TAPCELL_ROW_8_98 VSS VDD sky130_fd_sc_hd__tapvpwrvgnd_1
XTAP_TAPCELL_ROW_8_99 VSS VDD sky130_fd_sc_hd__tapvpwrvgnd_1
XTAP_TAPCELL_ROW_9_100 VSS VDD sky130_fd_sc_hd__tapvpwrvgnd_1
XTAP_TAPCELL_ROW_9_101 VSS VDD sky130_fd_sc_hd__tapvpwrvgnd_1
XTAP_TAPCELL_ROW_9_102 VSS VDD sky130_fd_sc_hd__tapvpwrvgnd_1
XTAP_TAPCELL_ROW_9_103 VSS VDD sky130_fd_sc_hd__tapvpwrvgnd_1
XTAP_TAPCELL_ROW_9_104 VSS VDD sky130_fd_sc_hd__tapvpwrvgnd_1
XTAP_TAPCELL_ROW_9_105 VSS VDD sky130_fd_sc_hd__tapvpwrvgnd_1
XTAP_TAPCELL_ROW_9_106 VSS VDD sky130_fd_sc_hd__tapvpwrvgnd_1
XTAP_TAPCELL_ROW_9_107 VSS VDD sky130_fd_sc_hd__tapvpwrvgnd_1
XTAP_TAPCELL_ROW_9_108 VSS VDD sky130_fd_sc_hd__tapvpwrvgnd_1
XTAP_TAPCELL_ROW_9_109 VSS VDD sky130_fd_sc_hd__tapvpwrvgnd_1
XTAP_TAPCELL_ROW_10_110 VSS VDD sky130_fd_sc_hd__tapvpwrvgnd_1
XTAP_TAPCELL_ROW_10_111 VSS VDD sky130_fd_sc_hd__tapvpwrvgnd_1
XTAP_TAPCELL_ROW_10_112 VSS VDD sky130_fd_sc_hd__tapvpwrvgnd_1
XTAP_TAPCELL_ROW_10_113 VSS VDD sky130_fd_sc_hd__tapvpwrvgnd_1
XTAP_TAPCELL_ROW_10_114 VSS VDD sky130_fd_sc_hd__tapvpwrvgnd_1
XTAP_TAPCELL_ROW_10_115 VSS VDD sky130_fd_sc_hd__tapvpwrvgnd_1
XTAP_TAPCELL_ROW_10_116 VSS VDD sky130_fd_sc_hd__tapvpwrvgnd_1
XTAP_TAPCELL_ROW_10_117 VSS VDD sky130_fd_sc_hd__tapvpwrvgnd_1
XTAP_TAPCELL_ROW_10_118 VSS VDD sky130_fd_sc_hd__tapvpwrvgnd_1
XTAP_TAPCELL_ROW_10_119 VSS VDD sky130_fd_sc_hd__tapvpwrvgnd_1
XTAP_TAPCELL_ROW_11_120 VSS VDD sky130_fd_sc_hd__tapvpwrvgnd_1
XTAP_TAPCELL_ROW_11_121 VSS VDD sky130_fd_sc_hd__tapvpwrvgnd_1
XTAP_TAPCELL_ROW_11_122 VSS VDD sky130_fd_sc_hd__tapvpwrvgnd_1
XTAP_TAPCELL_ROW_11_123 VSS VDD sky130_fd_sc_hd__tapvpwrvgnd_1
XTAP_TAPCELL_ROW_11_124 VSS VDD sky130_fd_sc_hd__tapvpwrvgnd_1
XTAP_TAPCELL_ROW_11_125 VSS VDD sky130_fd_sc_hd__tapvpwrvgnd_1
XTAP_TAPCELL_ROW_11_126 VSS VDD sky130_fd_sc_hd__tapvpwrvgnd_1
XTAP_TAPCELL_ROW_11_127 VSS VDD sky130_fd_sc_hd__tapvpwrvgnd_1
XTAP_TAPCELL_ROW_11_128 VSS VDD sky130_fd_sc_hd__tapvpwrvgnd_1
XTAP_TAPCELL_ROW_11_129 VSS VDD sky130_fd_sc_hd__tapvpwrvgnd_1
XTAP_TAPCELL_ROW_12_130 VSS VDD sky130_fd_sc_hd__tapvpwrvgnd_1
XTAP_TAPCELL_ROW_12_131 VSS VDD sky130_fd_sc_hd__tapvpwrvgnd_1
XTAP_TAPCELL_ROW_12_132 VSS VDD sky130_fd_sc_hd__tapvpwrvgnd_1
XTAP_TAPCELL_ROW_12_133 VSS VDD sky130_fd_sc_hd__tapvpwrvgnd_1
XTAP_TAPCELL_ROW_12_134 VSS VDD sky130_fd_sc_hd__tapvpwrvgnd_1
XTAP_TAPCELL_ROW_12_135 VSS VDD sky130_fd_sc_hd__tapvpwrvgnd_1
XTAP_TAPCELL_ROW_12_136 VSS VDD sky130_fd_sc_hd__tapvpwrvgnd_1
XTAP_TAPCELL_ROW_12_137 VSS VDD sky130_fd_sc_hd__tapvpwrvgnd_1
XTAP_TAPCELL_ROW_12_138 VSS VDD sky130_fd_sc_hd__tapvpwrvgnd_1
XTAP_TAPCELL_ROW_12_139 VSS VDD sky130_fd_sc_hd__tapvpwrvgnd_1
XTAP_TAPCELL_ROW_13_140 VSS VDD sky130_fd_sc_hd__tapvpwrvgnd_1
XTAP_TAPCELL_ROW_13_141 VSS VDD sky130_fd_sc_hd__tapvpwrvgnd_1
XTAP_TAPCELL_ROW_13_142 VSS VDD sky130_fd_sc_hd__tapvpwrvgnd_1
XTAP_TAPCELL_ROW_13_143 VSS VDD sky130_fd_sc_hd__tapvpwrvgnd_1
XTAP_TAPCELL_ROW_13_144 VSS VDD sky130_fd_sc_hd__tapvpwrvgnd_1
XTAP_TAPCELL_ROW_13_145 VSS VDD sky130_fd_sc_hd__tapvpwrvgnd_1
XTAP_TAPCELL_ROW_13_146 VSS VDD sky130_fd_sc_hd__tapvpwrvgnd_1
XTAP_TAPCELL_ROW_13_147 VSS VDD sky130_fd_sc_hd__tapvpwrvgnd_1
XTAP_TAPCELL_ROW_13_148 VSS VDD sky130_fd_sc_hd__tapvpwrvgnd_1
XTAP_TAPCELL_ROW_13_149 VSS VDD sky130_fd_sc_hd__tapvpwrvgnd_1
XTAP_TAPCELL_ROW_14_150 VSS VDD sky130_fd_sc_hd__tapvpwrvgnd_1
XTAP_TAPCELL_ROW_14_151 VSS VDD sky130_fd_sc_hd__tapvpwrvgnd_1
XTAP_TAPCELL_ROW_14_152 VSS VDD sky130_fd_sc_hd__tapvpwrvgnd_1
XTAP_TAPCELL_ROW_14_153 VSS VDD sky130_fd_sc_hd__tapvpwrvgnd_1
XTAP_TAPCELL_ROW_14_154 VSS VDD sky130_fd_sc_hd__tapvpwrvgnd_1
XTAP_TAPCELL_ROW_14_155 VSS VDD sky130_fd_sc_hd__tapvpwrvgnd_1
XTAP_TAPCELL_ROW_14_156 VSS VDD sky130_fd_sc_hd__tapvpwrvgnd_1
XTAP_TAPCELL_ROW_14_157 VSS VDD sky130_fd_sc_hd__tapvpwrvgnd_1
XTAP_TAPCELL_ROW_14_158 VSS VDD sky130_fd_sc_hd__tapvpwrvgnd_1
XTAP_TAPCELL_ROW_14_159 VSS VDD sky130_fd_sc_hd__tapvpwrvgnd_1
XTAP_TAPCELL_ROW_15_160 VSS VDD sky130_fd_sc_hd__tapvpwrvgnd_1
XTAP_TAPCELL_ROW_15_161 VSS VDD sky130_fd_sc_hd__tapvpwrvgnd_1
XTAP_TAPCELL_ROW_15_162 VSS VDD sky130_fd_sc_hd__tapvpwrvgnd_1
XTAP_TAPCELL_ROW_15_163 VSS VDD sky130_fd_sc_hd__tapvpwrvgnd_1
XTAP_TAPCELL_ROW_15_164 VSS VDD sky130_fd_sc_hd__tapvpwrvgnd_1
XTAP_TAPCELL_ROW_15_165 VSS VDD sky130_fd_sc_hd__tapvpwrvgnd_1
XTAP_TAPCELL_ROW_15_166 VSS VDD sky130_fd_sc_hd__tapvpwrvgnd_1
XTAP_TAPCELL_ROW_15_167 VSS VDD sky130_fd_sc_hd__tapvpwrvgnd_1
XTAP_TAPCELL_ROW_15_168 VSS VDD sky130_fd_sc_hd__tapvpwrvgnd_1
XTAP_TAPCELL_ROW_15_169 VSS VDD sky130_fd_sc_hd__tapvpwrvgnd_1
XTAP_TAPCELL_ROW_16_170 VSS VDD sky130_fd_sc_hd__tapvpwrvgnd_1
XTAP_TAPCELL_ROW_16_171 VSS VDD sky130_fd_sc_hd__tapvpwrvgnd_1
XTAP_TAPCELL_ROW_16_172 VSS VDD sky130_fd_sc_hd__tapvpwrvgnd_1
XTAP_TAPCELL_ROW_16_173 VSS VDD sky130_fd_sc_hd__tapvpwrvgnd_1
XTAP_TAPCELL_ROW_16_174 VSS VDD sky130_fd_sc_hd__tapvpwrvgnd_1
XTAP_TAPCELL_ROW_16_175 VSS VDD sky130_fd_sc_hd__tapvpwrvgnd_1
XTAP_TAPCELL_ROW_16_176 VSS VDD sky130_fd_sc_hd__tapvpwrvgnd_1
XTAP_TAPCELL_ROW_16_177 VSS VDD sky130_fd_sc_hd__tapvpwrvgnd_1
XTAP_TAPCELL_ROW_16_178 VSS VDD sky130_fd_sc_hd__tapvpwrvgnd_1
XTAP_TAPCELL_ROW_16_179 VSS VDD sky130_fd_sc_hd__tapvpwrvgnd_1
XTAP_TAPCELL_ROW_17_180 VSS VDD sky130_fd_sc_hd__tapvpwrvgnd_1
XTAP_TAPCELL_ROW_17_181 VSS VDD sky130_fd_sc_hd__tapvpwrvgnd_1
XTAP_TAPCELL_ROW_17_182 VSS VDD sky130_fd_sc_hd__tapvpwrvgnd_1
XTAP_TAPCELL_ROW_17_183 VSS VDD sky130_fd_sc_hd__tapvpwrvgnd_1
XTAP_TAPCELL_ROW_17_184 VSS VDD sky130_fd_sc_hd__tapvpwrvgnd_1
XTAP_TAPCELL_ROW_17_185 VSS VDD sky130_fd_sc_hd__tapvpwrvgnd_1
XTAP_TAPCELL_ROW_17_186 VSS VDD sky130_fd_sc_hd__tapvpwrvgnd_1
XTAP_TAPCELL_ROW_17_187 VSS VDD sky130_fd_sc_hd__tapvpwrvgnd_1
XTAP_TAPCELL_ROW_17_188 VSS VDD sky130_fd_sc_hd__tapvpwrvgnd_1
XTAP_TAPCELL_ROW_17_189 VSS VDD sky130_fd_sc_hd__tapvpwrvgnd_1
XTAP_TAPCELL_ROW_18_190 VSS VDD sky130_fd_sc_hd__tapvpwrvgnd_1
XTAP_TAPCELL_ROW_18_191 VSS VDD sky130_fd_sc_hd__tapvpwrvgnd_1
XTAP_TAPCELL_ROW_18_192 VSS VDD sky130_fd_sc_hd__tapvpwrvgnd_1
XTAP_TAPCELL_ROW_18_193 VSS VDD sky130_fd_sc_hd__tapvpwrvgnd_1
XTAP_TAPCELL_ROW_18_194 VSS VDD sky130_fd_sc_hd__tapvpwrvgnd_1
XTAP_TAPCELL_ROW_18_195 VSS VDD sky130_fd_sc_hd__tapvpwrvgnd_1
XTAP_TAPCELL_ROW_18_196 VSS VDD sky130_fd_sc_hd__tapvpwrvgnd_1
XTAP_TAPCELL_ROW_18_197 VSS VDD sky130_fd_sc_hd__tapvpwrvgnd_1
XTAP_TAPCELL_ROW_18_198 VSS VDD sky130_fd_sc_hd__tapvpwrvgnd_1
XTAP_TAPCELL_ROW_18_199 VSS VDD sky130_fd_sc_hd__tapvpwrvgnd_1
XTAP_TAPCELL_ROW_19_200 VSS VDD sky130_fd_sc_hd__tapvpwrvgnd_1
XTAP_TAPCELL_ROW_19_201 VSS VDD sky130_fd_sc_hd__tapvpwrvgnd_1
XTAP_TAPCELL_ROW_19_202 VSS VDD sky130_fd_sc_hd__tapvpwrvgnd_1
XTAP_TAPCELL_ROW_19_203 VSS VDD sky130_fd_sc_hd__tapvpwrvgnd_1
XTAP_TAPCELL_ROW_19_204 VSS VDD sky130_fd_sc_hd__tapvpwrvgnd_1
XTAP_TAPCELL_ROW_19_205 VSS VDD sky130_fd_sc_hd__tapvpwrvgnd_1
XTAP_TAPCELL_ROW_19_206 VSS VDD sky130_fd_sc_hd__tapvpwrvgnd_1
XTAP_TAPCELL_ROW_19_207 VSS VDD sky130_fd_sc_hd__tapvpwrvgnd_1
XTAP_TAPCELL_ROW_19_208 VSS VDD sky130_fd_sc_hd__tapvpwrvgnd_1
XTAP_TAPCELL_ROW_19_209 VSS VDD sky130_fd_sc_hd__tapvpwrvgnd_1
XTAP_TAPCELL_ROW_20_210 VSS VDD sky130_fd_sc_hd__tapvpwrvgnd_1
XTAP_TAPCELL_ROW_20_211 VSS VDD sky130_fd_sc_hd__tapvpwrvgnd_1
XTAP_TAPCELL_ROW_20_212 VSS VDD sky130_fd_sc_hd__tapvpwrvgnd_1
XTAP_TAPCELL_ROW_20_213 VSS VDD sky130_fd_sc_hd__tapvpwrvgnd_1
XTAP_TAPCELL_ROW_20_214 VSS VDD sky130_fd_sc_hd__tapvpwrvgnd_1
XTAP_TAPCELL_ROW_20_215 VSS VDD sky130_fd_sc_hd__tapvpwrvgnd_1
XTAP_TAPCELL_ROW_20_216 VSS VDD sky130_fd_sc_hd__tapvpwrvgnd_1
XTAP_TAPCELL_ROW_20_217 VSS VDD sky130_fd_sc_hd__tapvpwrvgnd_1
XTAP_TAPCELL_ROW_20_218 VSS VDD sky130_fd_sc_hd__tapvpwrvgnd_1
XTAP_TAPCELL_ROW_20_219 VSS VDD sky130_fd_sc_hd__tapvpwrvgnd_1
XTAP_TAPCELL_ROW_21_220 VSS VDD sky130_fd_sc_hd__tapvpwrvgnd_1
XTAP_TAPCELL_ROW_21_221 VSS VDD sky130_fd_sc_hd__tapvpwrvgnd_1
XTAP_TAPCELL_ROW_21_222 VSS VDD sky130_fd_sc_hd__tapvpwrvgnd_1
XTAP_TAPCELL_ROW_21_223 VSS VDD sky130_fd_sc_hd__tapvpwrvgnd_1
XTAP_TAPCELL_ROW_21_224 VSS VDD sky130_fd_sc_hd__tapvpwrvgnd_1
XTAP_TAPCELL_ROW_21_225 VSS VDD sky130_fd_sc_hd__tapvpwrvgnd_1
XTAP_TAPCELL_ROW_21_226 VSS VDD sky130_fd_sc_hd__tapvpwrvgnd_1
XTAP_TAPCELL_ROW_21_227 VSS VDD sky130_fd_sc_hd__tapvpwrvgnd_1
XTAP_TAPCELL_ROW_21_228 VSS VDD sky130_fd_sc_hd__tapvpwrvgnd_1
XTAP_TAPCELL_ROW_21_229 VSS VDD sky130_fd_sc_hd__tapvpwrvgnd_1
XTAP_TAPCELL_ROW_22_230 VSS VDD sky130_fd_sc_hd__tapvpwrvgnd_1
XTAP_TAPCELL_ROW_22_231 VSS VDD sky130_fd_sc_hd__tapvpwrvgnd_1
XTAP_TAPCELL_ROW_22_232 VSS VDD sky130_fd_sc_hd__tapvpwrvgnd_1
XTAP_TAPCELL_ROW_22_233 VSS VDD sky130_fd_sc_hd__tapvpwrvgnd_1
XTAP_TAPCELL_ROW_22_234 VSS VDD sky130_fd_sc_hd__tapvpwrvgnd_1
XTAP_TAPCELL_ROW_22_235 VSS VDD sky130_fd_sc_hd__tapvpwrvgnd_1
XTAP_TAPCELL_ROW_22_236 VSS VDD sky130_fd_sc_hd__tapvpwrvgnd_1
XTAP_TAPCELL_ROW_22_237 VSS VDD sky130_fd_sc_hd__tapvpwrvgnd_1
XTAP_TAPCELL_ROW_22_238 VSS VDD sky130_fd_sc_hd__tapvpwrvgnd_1
XTAP_TAPCELL_ROW_22_239 VSS VDD sky130_fd_sc_hd__tapvpwrvgnd_1
XTAP_TAPCELL_ROW_23_240 VSS VDD sky130_fd_sc_hd__tapvpwrvgnd_1
XTAP_TAPCELL_ROW_23_241 VSS VDD sky130_fd_sc_hd__tapvpwrvgnd_1
XTAP_TAPCELL_ROW_23_242 VSS VDD sky130_fd_sc_hd__tapvpwrvgnd_1
XTAP_TAPCELL_ROW_23_243 VSS VDD sky130_fd_sc_hd__tapvpwrvgnd_1
XTAP_TAPCELL_ROW_23_244 VSS VDD sky130_fd_sc_hd__tapvpwrvgnd_1
XTAP_TAPCELL_ROW_23_245 VSS VDD sky130_fd_sc_hd__tapvpwrvgnd_1
XTAP_TAPCELL_ROW_23_246 VSS VDD sky130_fd_sc_hd__tapvpwrvgnd_1
XTAP_TAPCELL_ROW_23_247 VSS VDD sky130_fd_sc_hd__tapvpwrvgnd_1
XTAP_TAPCELL_ROW_23_248 VSS VDD sky130_fd_sc_hd__tapvpwrvgnd_1
XTAP_TAPCELL_ROW_23_249 VSS VDD sky130_fd_sc_hd__tapvpwrvgnd_1
XTAP_TAPCELL_ROW_24_250 VSS VDD sky130_fd_sc_hd__tapvpwrvgnd_1
XTAP_TAPCELL_ROW_24_251 VSS VDD sky130_fd_sc_hd__tapvpwrvgnd_1
XTAP_TAPCELL_ROW_24_252 VSS VDD sky130_fd_sc_hd__tapvpwrvgnd_1
XTAP_TAPCELL_ROW_24_253 VSS VDD sky130_fd_sc_hd__tapvpwrvgnd_1
XTAP_TAPCELL_ROW_24_254 VSS VDD sky130_fd_sc_hd__tapvpwrvgnd_1
XTAP_TAPCELL_ROW_24_255 VSS VDD sky130_fd_sc_hd__tapvpwrvgnd_1
XTAP_TAPCELL_ROW_24_256 VSS VDD sky130_fd_sc_hd__tapvpwrvgnd_1
XTAP_TAPCELL_ROW_24_257 VSS VDD sky130_fd_sc_hd__tapvpwrvgnd_1
XTAP_TAPCELL_ROW_24_258 VSS VDD sky130_fd_sc_hd__tapvpwrvgnd_1
XTAP_TAPCELL_ROW_24_259 VSS VDD sky130_fd_sc_hd__tapvpwrvgnd_1
XTAP_TAPCELL_ROW_25_260 VSS VDD sky130_fd_sc_hd__tapvpwrvgnd_1
XTAP_TAPCELL_ROW_25_261 VSS VDD sky130_fd_sc_hd__tapvpwrvgnd_1
XTAP_TAPCELL_ROW_25_262 VSS VDD sky130_fd_sc_hd__tapvpwrvgnd_1
XTAP_TAPCELL_ROW_25_263 VSS VDD sky130_fd_sc_hd__tapvpwrvgnd_1
XTAP_TAPCELL_ROW_25_264 VSS VDD sky130_fd_sc_hd__tapvpwrvgnd_1
XTAP_TAPCELL_ROW_25_265 VSS VDD sky130_fd_sc_hd__tapvpwrvgnd_1
XTAP_TAPCELL_ROW_25_266 VSS VDD sky130_fd_sc_hd__tapvpwrvgnd_1
XTAP_TAPCELL_ROW_25_267 VSS VDD sky130_fd_sc_hd__tapvpwrvgnd_1
XTAP_TAPCELL_ROW_25_268 VSS VDD sky130_fd_sc_hd__tapvpwrvgnd_1
XTAP_TAPCELL_ROW_25_269 VSS VDD sky130_fd_sc_hd__tapvpwrvgnd_1
XTAP_TAPCELL_ROW_26_270 VSS VDD sky130_fd_sc_hd__tapvpwrvgnd_1
XTAP_TAPCELL_ROW_26_271 VSS VDD sky130_fd_sc_hd__tapvpwrvgnd_1
XTAP_TAPCELL_ROW_26_272 VSS VDD sky130_fd_sc_hd__tapvpwrvgnd_1
XTAP_TAPCELL_ROW_26_273 VSS VDD sky130_fd_sc_hd__tapvpwrvgnd_1
XTAP_TAPCELL_ROW_26_274 VSS VDD sky130_fd_sc_hd__tapvpwrvgnd_1
XTAP_TAPCELL_ROW_26_275 VSS VDD sky130_fd_sc_hd__tapvpwrvgnd_1
XTAP_TAPCELL_ROW_26_276 VSS VDD sky130_fd_sc_hd__tapvpwrvgnd_1
XTAP_TAPCELL_ROW_26_277 VSS VDD sky130_fd_sc_hd__tapvpwrvgnd_1
XTAP_TAPCELL_ROW_26_278 VSS VDD sky130_fd_sc_hd__tapvpwrvgnd_1
XTAP_TAPCELL_ROW_26_279 VSS VDD sky130_fd_sc_hd__tapvpwrvgnd_1
XTAP_TAPCELL_ROW_27_280 VSS VDD sky130_fd_sc_hd__tapvpwrvgnd_1
XTAP_TAPCELL_ROW_27_281 VSS VDD sky130_fd_sc_hd__tapvpwrvgnd_1
XTAP_TAPCELL_ROW_27_282 VSS VDD sky130_fd_sc_hd__tapvpwrvgnd_1
XTAP_TAPCELL_ROW_27_283 VSS VDD sky130_fd_sc_hd__tapvpwrvgnd_1
XTAP_TAPCELL_ROW_27_284 VSS VDD sky130_fd_sc_hd__tapvpwrvgnd_1
XTAP_TAPCELL_ROW_27_285 VSS VDD sky130_fd_sc_hd__tapvpwrvgnd_1
XTAP_TAPCELL_ROW_27_286 VSS VDD sky130_fd_sc_hd__tapvpwrvgnd_1
XTAP_TAPCELL_ROW_27_287 VSS VDD sky130_fd_sc_hd__tapvpwrvgnd_1
XTAP_TAPCELL_ROW_27_288 VSS VDD sky130_fd_sc_hd__tapvpwrvgnd_1
XTAP_TAPCELL_ROW_27_289 VSS VDD sky130_fd_sc_hd__tapvpwrvgnd_1
XTAP_TAPCELL_ROW_28_290 VSS VDD sky130_fd_sc_hd__tapvpwrvgnd_1
XTAP_TAPCELL_ROW_28_291 VSS VDD sky130_fd_sc_hd__tapvpwrvgnd_1
XTAP_TAPCELL_ROW_28_292 VSS VDD sky130_fd_sc_hd__tapvpwrvgnd_1
XTAP_TAPCELL_ROW_28_293 VSS VDD sky130_fd_sc_hd__tapvpwrvgnd_1
XTAP_TAPCELL_ROW_28_294 VSS VDD sky130_fd_sc_hd__tapvpwrvgnd_1
XTAP_TAPCELL_ROW_28_295 VSS VDD sky130_fd_sc_hd__tapvpwrvgnd_1
XTAP_TAPCELL_ROW_28_296 VSS VDD sky130_fd_sc_hd__tapvpwrvgnd_1
XTAP_TAPCELL_ROW_28_297 VSS VDD sky130_fd_sc_hd__tapvpwrvgnd_1
XTAP_TAPCELL_ROW_28_298 VSS VDD sky130_fd_sc_hd__tapvpwrvgnd_1
XTAP_TAPCELL_ROW_28_299 VSS VDD sky130_fd_sc_hd__tapvpwrvgnd_1
XTAP_TAPCELL_ROW_29_300 VSS VDD sky130_fd_sc_hd__tapvpwrvgnd_1
XTAP_TAPCELL_ROW_29_301 VSS VDD sky130_fd_sc_hd__tapvpwrvgnd_1
XTAP_TAPCELL_ROW_29_302 VSS VDD sky130_fd_sc_hd__tapvpwrvgnd_1
XTAP_TAPCELL_ROW_29_303 VSS VDD sky130_fd_sc_hd__tapvpwrvgnd_1
XTAP_TAPCELL_ROW_29_304 VSS VDD sky130_fd_sc_hd__tapvpwrvgnd_1
XTAP_TAPCELL_ROW_29_305 VSS VDD sky130_fd_sc_hd__tapvpwrvgnd_1
XTAP_TAPCELL_ROW_29_306 VSS VDD sky130_fd_sc_hd__tapvpwrvgnd_1
XTAP_TAPCELL_ROW_29_307 VSS VDD sky130_fd_sc_hd__tapvpwrvgnd_1
XTAP_TAPCELL_ROW_29_308 VSS VDD sky130_fd_sc_hd__tapvpwrvgnd_1
XTAP_TAPCELL_ROW_29_309 VSS VDD sky130_fd_sc_hd__tapvpwrvgnd_1
XTAP_TAPCELL_ROW_30_310 VSS VDD sky130_fd_sc_hd__tapvpwrvgnd_1
XTAP_TAPCELL_ROW_30_311 VSS VDD sky130_fd_sc_hd__tapvpwrvgnd_1
XTAP_TAPCELL_ROW_30_312 VSS VDD sky130_fd_sc_hd__tapvpwrvgnd_1
XTAP_TAPCELL_ROW_30_313 VSS VDD sky130_fd_sc_hd__tapvpwrvgnd_1
XTAP_TAPCELL_ROW_30_314 VSS VDD sky130_fd_sc_hd__tapvpwrvgnd_1
XTAP_TAPCELL_ROW_30_315 VSS VDD sky130_fd_sc_hd__tapvpwrvgnd_1
XTAP_TAPCELL_ROW_30_316 VSS VDD sky130_fd_sc_hd__tapvpwrvgnd_1
XTAP_TAPCELL_ROW_30_317 VSS VDD sky130_fd_sc_hd__tapvpwrvgnd_1
XTAP_TAPCELL_ROW_30_318 VSS VDD sky130_fd_sc_hd__tapvpwrvgnd_1
XTAP_TAPCELL_ROW_30_319 VSS VDD sky130_fd_sc_hd__tapvpwrvgnd_1
XTAP_TAPCELL_ROW_31_320 VSS VDD sky130_fd_sc_hd__tapvpwrvgnd_1
XTAP_TAPCELL_ROW_31_321 VSS VDD sky130_fd_sc_hd__tapvpwrvgnd_1
XTAP_TAPCELL_ROW_31_322 VSS VDD sky130_fd_sc_hd__tapvpwrvgnd_1
XTAP_TAPCELL_ROW_31_323 VSS VDD sky130_fd_sc_hd__tapvpwrvgnd_1
XTAP_TAPCELL_ROW_31_324 VSS VDD sky130_fd_sc_hd__tapvpwrvgnd_1
XTAP_TAPCELL_ROW_31_325 VSS VDD sky130_fd_sc_hd__tapvpwrvgnd_1
XTAP_TAPCELL_ROW_31_326 VSS VDD sky130_fd_sc_hd__tapvpwrvgnd_1
XTAP_TAPCELL_ROW_31_327 VSS VDD sky130_fd_sc_hd__tapvpwrvgnd_1
XTAP_TAPCELL_ROW_31_328 VSS VDD sky130_fd_sc_hd__tapvpwrvgnd_1
XTAP_TAPCELL_ROW_31_329 VSS VDD sky130_fd_sc_hd__tapvpwrvgnd_1
XTAP_TAPCELL_ROW_32_330 VSS VDD sky130_fd_sc_hd__tapvpwrvgnd_1
XTAP_TAPCELL_ROW_32_331 VSS VDD sky130_fd_sc_hd__tapvpwrvgnd_1
XTAP_TAPCELL_ROW_32_332 VSS VDD sky130_fd_sc_hd__tapvpwrvgnd_1
XTAP_TAPCELL_ROW_32_333 VSS VDD sky130_fd_sc_hd__tapvpwrvgnd_1
XTAP_TAPCELL_ROW_32_334 VSS VDD sky130_fd_sc_hd__tapvpwrvgnd_1
XTAP_TAPCELL_ROW_32_335 VSS VDD sky130_fd_sc_hd__tapvpwrvgnd_1
XTAP_TAPCELL_ROW_32_336 VSS VDD sky130_fd_sc_hd__tapvpwrvgnd_1
XTAP_TAPCELL_ROW_32_337 VSS VDD sky130_fd_sc_hd__tapvpwrvgnd_1
XTAP_TAPCELL_ROW_32_338 VSS VDD sky130_fd_sc_hd__tapvpwrvgnd_1
XTAP_TAPCELL_ROW_32_339 VSS VDD sky130_fd_sc_hd__tapvpwrvgnd_1
XTAP_TAPCELL_ROW_33_340 VSS VDD sky130_fd_sc_hd__tapvpwrvgnd_1
XTAP_TAPCELL_ROW_33_341 VSS VDD sky130_fd_sc_hd__tapvpwrvgnd_1
XTAP_TAPCELL_ROW_33_342 VSS VDD sky130_fd_sc_hd__tapvpwrvgnd_1
XTAP_TAPCELL_ROW_33_343 VSS VDD sky130_fd_sc_hd__tapvpwrvgnd_1
XTAP_TAPCELL_ROW_33_344 VSS VDD sky130_fd_sc_hd__tapvpwrvgnd_1
XTAP_TAPCELL_ROW_33_345 VSS VDD sky130_fd_sc_hd__tapvpwrvgnd_1
XTAP_TAPCELL_ROW_33_346 VSS VDD sky130_fd_sc_hd__tapvpwrvgnd_1
XTAP_TAPCELL_ROW_33_347 VSS VDD sky130_fd_sc_hd__tapvpwrvgnd_1
XTAP_TAPCELL_ROW_33_348 VSS VDD sky130_fd_sc_hd__tapvpwrvgnd_1
XTAP_TAPCELL_ROW_33_349 VSS VDD sky130_fd_sc_hd__tapvpwrvgnd_1
XTAP_TAPCELL_ROW_34_350 VSS VDD sky130_fd_sc_hd__tapvpwrvgnd_1
XTAP_TAPCELL_ROW_34_351 VSS VDD sky130_fd_sc_hd__tapvpwrvgnd_1
XTAP_TAPCELL_ROW_34_352 VSS VDD sky130_fd_sc_hd__tapvpwrvgnd_1
XTAP_TAPCELL_ROW_34_353 VSS VDD sky130_fd_sc_hd__tapvpwrvgnd_1
XTAP_TAPCELL_ROW_34_354 VSS VDD sky130_fd_sc_hd__tapvpwrvgnd_1
XTAP_TAPCELL_ROW_34_355 VSS VDD sky130_fd_sc_hd__tapvpwrvgnd_1
XTAP_TAPCELL_ROW_34_356 VSS VDD sky130_fd_sc_hd__tapvpwrvgnd_1
XTAP_TAPCELL_ROW_34_357 VSS VDD sky130_fd_sc_hd__tapvpwrvgnd_1
XTAP_TAPCELL_ROW_34_358 VSS VDD sky130_fd_sc_hd__tapvpwrvgnd_1
XTAP_TAPCELL_ROW_34_359 VSS VDD sky130_fd_sc_hd__tapvpwrvgnd_1
XTAP_TAPCELL_ROW_35_360 VSS VDD sky130_fd_sc_hd__tapvpwrvgnd_1
XTAP_TAPCELL_ROW_35_361 VSS VDD sky130_fd_sc_hd__tapvpwrvgnd_1
XTAP_TAPCELL_ROW_35_362 VSS VDD sky130_fd_sc_hd__tapvpwrvgnd_1
XTAP_TAPCELL_ROW_35_363 VSS VDD sky130_fd_sc_hd__tapvpwrvgnd_1
XTAP_TAPCELL_ROW_35_364 VSS VDD sky130_fd_sc_hd__tapvpwrvgnd_1
XTAP_TAPCELL_ROW_35_365 VSS VDD sky130_fd_sc_hd__tapvpwrvgnd_1
XTAP_TAPCELL_ROW_35_366 VSS VDD sky130_fd_sc_hd__tapvpwrvgnd_1
XTAP_TAPCELL_ROW_35_367 VSS VDD sky130_fd_sc_hd__tapvpwrvgnd_1
XTAP_TAPCELL_ROW_35_368 VSS VDD sky130_fd_sc_hd__tapvpwrvgnd_1
XTAP_TAPCELL_ROW_35_369 VSS VDD sky130_fd_sc_hd__tapvpwrvgnd_1
XTAP_TAPCELL_ROW_36_370 VSS VDD sky130_fd_sc_hd__tapvpwrvgnd_1
XTAP_TAPCELL_ROW_36_371 VSS VDD sky130_fd_sc_hd__tapvpwrvgnd_1
XTAP_TAPCELL_ROW_36_372 VSS VDD sky130_fd_sc_hd__tapvpwrvgnd_1
XTAP_TAPCELL_ROW_36_373 VSS VDD sky130_fd_sc_hd__tapvpwrvgnd_1
XTAP_TAPCELL_ROW_36_374 VSS VDD sky130_fd_sc_hd__tapvpwrvgnd_1
XTAP_TAPCELL_ROW_36_375 VSS VDD sky130_fd_sc_hd__tapvpwrvgnd_1
XTAP_TAPCELL_ROW_36_376 VSS VDD sky130_fd_sc_hd__tapvpwrvgnd_1
XTAP_TAPCELL_ROW_36_377 VSS VDD sky130_fd_sc_hd__tapvpwrvgnd_1
XTAP_TAPCELL_ROW_36_378 VSS VDD sky130_fd_sc_hd__tapvpwrvgnd_1
XTAP_TAPCELL_ROW_36_379 VSS VDD sky130_fd_sc_hd__tapvpwrvgnd_1
XTAP_TAPCELL_ROW_37_380 VSS VDD sky130_fd_sc_hd__tapvpwrvgnd_1
XTAP_TAPCELL_ROW_37_381 VSS VDD sky130_fd_sc_hd__tapvpwrvgnd_1
XTAP_TAPCELL_ROW_37_382 VSS VDD sky130_fd_sc_hd__tapvpwrvgnd_1
XTAP_TAPCELL_ROW_37_383 VSS VDD sky130_fd_sc_hd__tapvpwrvgnd_1
XTAP_TAPCELL_ROW_37_384 VSS VDD sky130_fd_sc_hd__tapvpwrvgnd_1
XTAP_TAPCELL_ROW_37_385 VSS VDD sky130_fd_sc_hd__tapvpwrvgnd_1
XTAP_TAPCELL_ROW_37_386 VSS VDD sky130_fd_sc_hd__tapvpwrvgnd_1
XTAP_TAPCELL_ROW_37_387 VSS VDD sky130_fd_sc_hd__tapvpwrvgnd_1
XTAP_TAPCELL_ROW_37_388 VSS VDD sky130_fd_sc_hd__tapvpwrvgnd_1
XTAP_TAPCELL_ROW_37_389 VSS VDD sky130_fd_sc_hd__tapvpwrvgnd_1
XTAP_TAPCELL_ROW_38_390 VSS VDD sky130_fd_sc_hd__tapvpwrvgnd_1
XTAP_TAPCELL_ROW_38_391 VSS VDD sky130_fd_sc_hd__tapvpwrvgnd_1
XTAP_TAPCELL_ROW_38_392 VSS VDD sky130_fd_sc_hd__tapvpwrvgnd_1
XTAP_TAPCELL_ROW_38_393 VSS VDD sky130_fd_sc_hd__tapvpwrvgnd_1
XTAP_TAPCELL_ROW_38_394 VSS VDD sky130_fd_sc_hd__tapvpwrvgnd_1
XTAP_TAPCELL_ROW_38_395 VSS VDD sky130_fd_sc_hd__tapvpwrvgnd_1
XTAP_TAPCELL_ROW_38_396 VSS VDD sky130_fd_sc_hd__tapvpwrvgnd_1
XTAP_TAPCELL_ROW_38_397 VSS VDD sky130_fd_sc_hd__tapvpwrvgnd_1
XTAP_TAPCELL_ROW_38_398 VSS VDD sky130_fd_sc_hd__tapvpwrvgnd_1
XTAP_TAPCELL_ROW_38_399 VSS VDD sky130_fd_sc_hd__tapvpwrvgnd_1
XTAP_TAPCELL_ROW_39_400 VSS VDD sky130_fd_sc_hd__tapvpwrvgnd_1
XTAP_TAPCELL_ROW_39_401 VSS VDD sky130_fd_sc_hd__tapvpwrvgnd_1
XTAP_TAPCELL_ROW_39_402 VSS VDD sky130_fd_sc_hd__tapvpwrvgnd_1
XTAP_TAPCELL_ROW_39_403 VSS VDD sky130_fd_sc_hd__tapvpwrvgnd_1
XTAP_TAPCELL_ROW_39_404 VSS VDD sky130_fd_sc_hd__tapvpwrvgnd_1
XTAP_TAPCELL_ROW_39_405 VSS VDD sky130_fd_sc_hd__tapvpwrvgnd_1
XTAP_TAPCELL_ROW_39_406 VSS VDD sky130_fd_sc_hd__tapvpwrvgnd_1
XTAP_TAPCELL_ROW_39_407 VSS VDD sky130_fd_sc_hd__tapvpwrvgnd_1
XTAP_TAPCELL_ROW_39_408 VSS VDD sky130_fd_sc_hd__tapvpwrvgnd_1
XTAP_TAPCELL_ROW_39_409 VSS VDD sky130_fd_sc_hd__tapvpwrvgnd_1
XTAP_TAPCELL_ROW_40_410 VSS VDD sky130_fd_sc_hd__tapvpwrvgnd_1
XTAP_TAPCELL_ROW_40_411 VSS VDD sky130_fd_sc_hd__tapvpwrvgnd_1
XTAP_TAPCELL_ROW_40_412 VSS VDD sky130_fd_sc_hd__tapvpwrvgnd_1
XTAP_TAPCELL_ROW_40_413 VSS VDD sky130_fd_sc_hd__tapvpwrvgnd_1
XTAP_TAPCELL_ROW_40_414 VSS VDD sky130_fd_sc_hd__tapvpwrvgnd_1
XTAP_TAPCELL_ROW_40_415 VSS VDD sky130_fd_sc_hd__tapvpwrvgnd_1
XTAP_TAPCELL_ROW_40_416 VSS VDD sky130_fd_sc_hd__tapvpwrvgnd_1
XTAP_TAPCELL_ROW_40_417 VSS VDD sky130_fd_sc_hd__tapvpwrvgnd_1
XTAP_TAPCELL_ROW_40_418 VSS VDD sky130_fd_sc_hd__tapvpwrvgnd_1
XTAP_TAPCELL_ROW_40_419 VSS VDD sky130_fd_sc_hd__tapvpwrvgnd_1
XTAP_TAPCELL_ROW_41_420 VSS VDD sky130_fd_sc_hd__tapvpwrvgnd_1
XTAP_TAPCELL_ROW_41_421 VSS VDD sky130_fd_sc_hd__tapvpwrvgnd_1
XTAP_TAPCELL_ROW_41_422 VSS VDD sky130_fd_sc_hd__tapvpwrvgnd_1
XTAP_TAPCELL_ROW_41_423 VSS VDD sky130_fd_sc_hd__tapvpwrvgnd_1
XTAP_TAPCELL_ROW_41_424 VSS VDD sky130_fd_sc_hd__tapvpwrvgnd_1
XTAP_TAPCELL_ROW_41_425 VSS VDD sky130_fd_sc_hd__tapvpwrvgnd_1
XTAP_TAPCELL_ROW_41_426 VSS VDD sky130_fd_sc_hd__tapvpwrvgnd_1
XTAP_TAPCELL_ROW_41_427 VSS VDD sky130_fd_sc_hd__tapvpwrvgnd_1
XTAP_TAPCELL_ROW_41_428 VSS VDD sky130_fd_sc_hd__tapvpwrvgnd_1
XTAP_TAPCELL_ROW_41_429 VSS VDD sky130_fd_sc_hd__tapvpwrvgnd_1
XTAP_TAPCELL_ROW_42_430 VSS VDD sky130_fd_sc_hd__tapvpwrvgnd_1
XTAP_TAPCELL_ROW_42_431 VSS VDD sky130_fd_sc_hd__tapvpwrvgnd_1
XTAP_TAPCELL_ROW_42_432 VSS VDD sky130_fd_sc_hd__tapvpwrvgnd_1
XTAP_TAPCELL_ROW_42_433 VSS VDD sky130_fd_sc_hd__tapvpwrvgnd_1
XTAP_TAPCELL_ROW_42_434 VSS VDD sky130_fd_sc_hd__tapvpwrvgnd_1
XTAP_TAPCELL_ROW_42_435 VSS VDD sky130_fd_sc_hd__tapvpwrvgnd_1
XTAP_TAPCELL_ROW_42_436 VSS VDD sky130_fd_sc_hd__tapvpwrvgnd_1
XTAP_TAPCELL_ROW_42_437 VSS VDD sky130_fd_sc_hd__tapvpwrvgnd_1
XTAP_TAPCELL_ROW_42_438 VSS VDD sky130_fd_sc_hd__tapvpwrvgnd_1
XTAP_TAPCELL_ROW_42_439 VSS VDD sky130_fd_sc_hd__tapvpwrvgnd_1
XTAP_TAPCELL_ROW_43_440 VSS VDD sky130_fd_sc_hd__tapvpwrvgnd_1
XTAP_TAPCELL_ROW_43_441 VSS VDD sky130_fd_sc_hd__tapvpwrvgnd_1
XTAP_TAPCELL_ROW_43_442 VSS VDD sky130_fd_sc_hd__tapvpwrvgnd_1
XTAP_TAPCELL_ROW_43_443 VSS VDD sky130_fd_sc_hd__tapvpwrvgnd_1
XTAP_TAPCELL_ROW_43_444 VSS VDD sky130_fd_sc_hd__tapvpwrvgnd_1
XTAP_TAPCELL_ROW_43_445 VSS VDD sky130_fd_sc_hd__tapvpwrvgnd_1
XTAP_TAPCELL_ROW_43_446 VSS VDD sky130_fd_sc_hd__tapvpwrvgnd_1
XTAP_TAPCELL_ROW_43_447 VSS VDD sky130_fd_sc_hd__tapvpwrvgnd_1
XTAP_TAPCELL_ROW_43_448 VSS VDD sky130_fd_sc_hd__tapvpwrvgnd_1
XTAP_TAPCELL_ROW_43_449 VSS VDD sky130_fd_sc_hd__tapvpwrvgnd_1
XTAP_TAPCELL_ROW_44_450 VSS VDD sky130_fd_sc_hd__tapvpwrvgnd_1
XTAP_TAPCELL_ROW_44_451 VSS VDD sky130_fd_sc_hd__tapvpwrvgnd_1
XTAP_TAPCELL_ROW_44_452 VSS VDD sky130_fd_sc_hd__tapvpwrvgnd_1
XTAP_TAPCELL_ROW_44_453 VSS VDD sky130_fd_sc_hd__tapvpwrvgnd_1
XTAP_TAPCELL_ROW_44_454 VSS VDD sky130_fd_sc_hd__tapvpwrvgnd_1
XTAP_TAPCELL_ROW_44_455 VSS VDD sky130_fd_sc_hd__tapvpwrvgnd_1
XTAP_TAPCELL_ROW_44_456 VSS VDD sky130_fd_sc_hd__tapvpwrvgnd_1
XTAP_TAPCELL_ROW_44_457 VSS VDD sky130_fd_sc_hd__tapvpwrvgnd_1
XTAP_TAPCELL_ROW_44_458 VSS VDD sky130_fd_sc_hd__tapvpwrvgnd_1
XTAP_TAPCELL_ROW_44_459 VSS VDD sky130_fd_sc_hd__tapvpwrvgnd_1
XTAP_TAPCELL_ROW_45_460 VSS VDD sky130_fd_sc_hd__tapvpwrvgnd_1
XTAP_TAPCELL_ROW_45_461 VSS VDD sky130_fd_sc_hd__tapvpwrvgnd_1
XTAP_TAPCELL_ROW_45_462 VSS VDD sky130_fd_sc_hd__tapvpwrvgnd_1
XTAP_TAPCELL_ROW_45_463 VSS VDD sky130_fd_sc_hd__tapvpwrvgnd_1
XTAP_TAPCELL_ROW_45_464 VSS VDD sky130_fd_sc_hd__tapvpwrvgnd_1
XTAP_TAPCELL_ROW_45_465 VSS VDD sky130_fd_sc_hd__tapvpwrvgnd_1
XTAP_TAPCELL_ROW_45_466 VSS VDD sky130_fd_sc_hd__tapvpwrvgnd_1
XTAP_TAPCELL_ROW_45_467 VSS VDD sky130_fd_sc_hd__tapvpwrvgnd_1
XTAP_TAPCELL_ROW_45_468 VSS VDD sky130_fd_sc_hd__tapvpwrvgnd_1
XTAP_TAPCELL_ROW_45_469 VSS VDD sky130_fd_sc_hd__tapvpwrvgnd_1
XTAP_TAPCELL_ROW_46_470 VSS VDD sky130_fd_sc_hd__tapvpwrvgnd_1
XTAP_TAPCELL_ROW_46_471 VSS VDD sky130_fd_sc_hd__tapvpwrvgnd_1
XTAP_TAPCELL_ROW_46_472 VSS VDD sky130_fd_sc_hd__tapvpwrvgnd_1
XTAP_TAPCELL_ROW_46_473 VSS VDD sky130_fd_sc_hd__tapvpwrvgnd_1
XTAP_TAPCELL_ROW_46_474 VSS VDD sky130_fd_sc_hd__tapvpwrvgnd_1
XTAP_TAPCELL_ROW_46_475 VSS VDD sky130_fd_sc_hd__tapvpwrvgnd_1
XTAP_TAPCELL_ROW_46_476 VSS VDD sky130_fd_sc_hd__tapvpwrvgnd_1
XTAP_TAPCELL_ROW_46_477 VSS VDD sky130_fd_sc_hd__tapvpwrvgnd_1
XTAP_TAPCELL_ROW_46_478 VSS VDD sky130_fd_sc_hd__tapvpwrvgnd_1
XTAP_TAPCELL_ROW_46_479 VSS VDD sky130_fd_sc_hd__tapvpwrvgnd_1
XTAP_TAPCELL_ROW_47_480 VSS VDD sky130_fd_sc_hd__tapvpwrvgnd_1
XTAP_TAPCELL_ROW_47_481 VSS VDD sky130_fd_sc_hd__tapvpwrvgnd_1
XTAP_TAPCELL_ROW_47_482 VSS VDD sky130_fd_sc_hd__tapvpwrvgnd_1
XTAP_TAPCELL_ROW_47_483 VSS VDD sky130_fd_sc_hd__tapvpwrvgnd_1
XTAP_TAPCELL_ROW_47_484 VSS VDD sky130_fd_sc_hd__tapvpwrvgnd_1
XTAP_TAPCELL_ROW_47_485 VSS VDD sky130_fd_sc_hd__tapvpwrvgnd_1
XTAP_TAPCELL_ROW_47_486 VSS VDD sky130_fd_sc_hd__tapvpwrvgnd_1
XTAP_TAPCELL_ROW_47_487 VSS VDD sky130_fd_sc_hd__tapvpwrvgnd_1
XTAP_TAPCELL_ROW_47_488 VSS VDD sky130_fd_sc_hd__tapvpwrvgnd_1
XTAP_TAPCELL_ROW_47_489 VSS VDD sky130_fd_sc_hd__tapvpwrvgnd_1
XTAP_TAPCELL_ROW_48_490 VSS VDD sky130_fd_sc_hd__tapvpwrvgnd_1
XTAP_TAPCELL_ROW_48_491 VSS VDD sky130_fd_sc_hd__tapvpwrvgnd_1
XTAP_TAPCELL_ROW_48_492 VSS VDD sky130_fd_sc_hd__tapvpwrvgnd_1
XTAP_TAPCELL_ROW_48_493 VSS VDD sky130_fd_sc_hd__tapvpwrvgnd_1
XTAP_TAPCELL_ROW_48_494 VSS VDD sky130_fd_sc_hd__tapvpwrvgnd_1
XTAP_TAPCELL_ROW_48_495 VSS VDD sky130_fd_sc_hd__tapvpwrvgnd_1
XTAP_TAPCELL_ROW_48_496 VSS VDD sky130_fd_sc_hd__tapvpwrvgnd_1
XTAP_TAPCELL_ROW_48_497 VSS VDD sky130_fd_sc_hd__tapvpwrvgnd_1
XTAP_TAPCELL_ROW_48_498 VSS VDD sky130_fd_sc_hd__tapvpwrvgnd_1
XTAP_TAPCELL_ROW_48_499 VSS VDD sky130_fd_sc_hd__tapvpwrvgnd_1
XTAP_TAPCELL_ROW_49_500 VSS VDD sky130_fd_sc_hd__tapvpwrvgnd_1
XTAP_TAPCELL_ROW_49_501 VSS VDD sky130_fd_sc_hd__tapvpwrvgnd_1
XTAP_TAPCELL_ROW_49_502 VSS VDD sky130_fd_sc_hd__tapvpwrvgnd_1
XTAP_TAPCELL_ROW_49_503 VSS VDD sky130_fd_sc_hd__tapvpwrvgnd_1
XTAP_TAPCELL_ROW_49_504 VSS VDD sky130_fd_sc_hd__tapvpwrvgnd_1
XTAP_TAPCELL_ROW_49_505 VSS VDD sky130_fd_sc_hd__tapvpwrvgnd_1
XTAP_TAPCELL_ROW_49_506 VSS VDD sky130_fd_sc_hd__tapvpwrvgnd_1
XTAP_TAPCELL_ROW_49_507 VSS VDD sky130_fd_sc_hd__tapvpwrvgnd_1
XTAP_TAPCELL_ROW_49_508 VSS VDD sky130_fd_sc_hd__tapvpwrvgnd_1
XTAP_TAPCELL_ROW_49_509 VSS VDD sky130_fd_sc_hd__tapvpwrvgnd_1
XTAP_TAPCELL_ROW_50_510 VSS VDD sky130_fd_sc_hd__tapvpwrvgnd_1
XTAP_TAPCELL_ROW_50_511 VSS VDD sky130_fd_sc_hd__tapvpwrvgnd_1
XTAP_TAPCELL_ROW_50_512 VSS VDD sky130_fd_sc_hd__tapvpwrvgnd_1
XTAP_TAPCELL_ROW_50_513 VSS VDD sky130_fd_sc_hd__tapvpwrvgnd_1
XTAP_TAPCELL_ROW_50_514 VSS VDD sky130_fd_sc_hd__tapvpwrvgnd_1
XTAP_TAPCELL_ROW_50_515 VSS VDD sky130_fd_sc_hd__tapvpwrvgnd_1
XTAP_TAPCELL_ROW_50_516 VSS VDD sky130_fd_sc_hd__tapvpwrvgnd_1
XTAP_TAPCELL_ROW_50_517 VSS VDD sky130_fd_sc_hd__tapvpwrvgnd_1
XTAP_TAPCELL_ROW_50_518 VSS VDD sky130_fd_sc_hd__tapvpwrvgnd_1
XTAP_TAPCELL_ROW_50_519 VSS VDD sky130_fd_sc_hd__tapvpwrvgnd_1
XTAP_TAPCELL_ROW_51_520 VSS VDD sky130_fd_sc_hd__tapvpwrvgnd_1
XTAP_TAPCELL_ROW_51_521 VSS VDD sky130_fd_sc_hd__tapvpwrvgnd_1
XTAP_TAPCELL_ROW_51_522 VSS VDD sky130_fd_sc_hd__tapvpwrvgnd_1
XTAP_TAPCELL_ROW_51_523 VSS VDD sky130_fd_sc_hd__tapvpwrvgnd_1
XTAP_TAPCELL_ROW_51_524 VSS VDD sky130_fd_sc_hd__tapvpwrvgnd_1
XTAP_TAPCELL_ROW_51_525 VSS VDD sky130_fd_sc_hd__tapvpwrvgnd_1
XTAP_TAPCELL_ROW_51_526 VSS VDD sky130_fd_sc_hd__tapvpwrvgnd_1
XTAP_TAPCELL_ROW_51_527 VSS VDD sky130_fd_sc_hd__tapvpwrvgnd_1
XTAP_TAPCELL_ROW_51_528 VSS VDD sky130_fd_sc_hd__tapvpwrvgnd_1
XTAP_TAPCELL_ROW_51_529 VSS VDD sky130_fd_sc_hd__tapvpwrvgnd_1
XTAP_TAPCELL_ROW_52_530 VSS VDD sky130_fd_sc_hd__tapvpwrvgnd_1
XTAP_TAPCELL_ROW_52_531 VSS VDD sky130_fd_sc_hd__tapvpwrvgnd_1
XTAP_TAPCELL_ROW_52_532 VSS VDD sky130_fd_sc_hd__tapvpwrvgnd_1
XTAP_TAPCELL_ROW_52_533 VSS VDD sky130_fd_sc_hd__tapvpwrvgnd_1
XTAP_TAPCELL_ROW_52_534 VSS VDD sky130_fd_sc_hd__tapvpwrvgnd_1
XTAP_TAPCELL_ROW_52_535 VSS VDD sky130_fd_sc_hd__tapvpwrvgnd_1
XTAP_TAPCELL_ROW_52_536 VSS VDD sky130_fd_sc_hd__tapvpwrvgnd_1
XTAP_TAPCELL_ROW_52_537 VSS VDD sky130_fd_sc_hd__tapvpwrvgnd_1
XTAP_TAPCELL_ROW_52_538 VSS VDD sky130_fd_sc_hd__tapvpwrvgnd_1
XTAP_TAPCELL_ROW_52_539 VSS VDD sky130_fd_sc_hd__tapvpwrvgnd_1
XTAP_TAPCELL_ROW_53_540 VSS VDD sky130_fd_sc_hd__tapvpwrvgnd_1
XTAP_TAPCELL_ROW_53_541 VSS VDD sky130_fd_sc_hd__tapvpwrvgnd_1
XTAP_TAPCELL_ROW_53_542 VSS VDD sky130_fd_sc_hd__tapvpwrvgnd_1
XTAP_TAPCELL_ROW_53_543 VSS VDD sky130_fd_sc_hd__tapvpwrvgnd_1
XTAP_TAPCELL_ROW_53_544 VSS VDD sky130_fd_sc_hd__tapvpwrvgnd_1
XTAP_TAPCELL_ROW_53_545 VSS VDD sky130_fd_sc_hd__tapvpwrvgnd_1
XTAP_TAPCELL_ROW_53_546 VSS VDD sky130_fd_sc_hd__tapvpwrvgnd_1
XTAP_TAPCELL_ROW_53_547 VSS VDD sky130_fd_sc_hd__tapvpwrvgnd_1
XTAP_TAPCELL_ROW_53_548 VSS VDD sky130_fd_sc_hd__tapvpwrvgnd_1
XTAP_TAPCELL_ROW_53_549 VSS VDD sky130_fd_sc_hd__tapvpwrvgnd_1
XTAP_TAPCELL_ROW_54_550 VSS VDD sky130_fd_sc_hd__tapvpwrvgnd_1
XTAP_TAPCELL_ROW_54_551 VSS VDD sky130_fd_sc_hd__tapvpwrvgnd_1
XTAP_TAPCELL_ROW_54_552 VSS VDD sky130_fd_sc_hd__tapvpwrvgnd_1
XTAP_TAPCELL_ROW_54_553 VSS VDD sky130_fd_sc_hd__tapvpwrvgnd_1
XTAP_TAPCELL_ROW_54_554 VSS VDD sky130_fd_sc_hd__tapvpwrvgnd_1
XTAP_TAPCELL_ROW_54_555 VSS VDD sky130_fd_sc_hd__tapvpwrvgnd_1
XTAP_TAPCELL_ROW_54_556 VSS VDD sky130_fd_sc_hd__tapvpwrvgnd_1
XTAP_TAPCELL_ROW_54_557 VSS VDD sky130_fd_sc_hd__tapvpwrvgnd_1
XTAP_TAPCELL_ROW_54_558 VSS VDD sky130_fd_sc_hd__tapvpwrvgnd_1
XTAP_TAPCELL_ROW_54_559 VSS VDD sky130_fd_sc_hd__tapvpwrvgnd_1
XTAP_TAPCELL_ROW_55_560 VSS VDD sky130_fd_sc_hd__tapvpwrvgnd_1
XTAP_TAPCELL_ROW_55_561 VSS VDD sky130_fd_sc_hd__tapvpwrvgnd_1
XTAP_TAPCELL_ROW_55_562 VSS VDD sky130_fd_sc_hd__tapvpwrvgnd_1
XTAP_TAPCELL_ROW_55_563 VSS VDD sky130_fd_sc_hd__tapvpwrvgnd_1
XTAP_TAPCELL_ROW_55_564 VSS VDD sky130_fd_sc_hd__tapvpwrvgnd_1
XTAP_TAPCELL_ROW_55_565 VSS VDD sky130_fd_sc_hd__tapvpwrvgnd_1
XTAP_TAPCELL_ROW_55_566 VSS VDD sky130_fd_sc_hd__tapvpwrvgnd_1
XTAP_TAPCELL_ROW_55_567 VSS VDD sky130_fd_sc_hd__tapvpwrvgnd_1
XTAP_TAPCELL_ROW_55_568 VSS VDD sky130_fd_sc_hd__tapvpwrvgnd_1
XTAP_TAPCELL_ROW_55_569 VSS VDD sky130_fd_sc_hd__tapvpwrvgnd_1
XTAP_TAPCELL_ROW_56_570 VSS VDD sky130_fd_sc_hd__tapvpwrvgnd_1
XTAP_TAPCELL_ROW_56_571 VSS VDD sky130_fd_sc_hd__tapvpwrvgnd_1
XTAP_TAPCELL_ROW_56_572 VSS VDD sky130_fd_sc_hd__tapvpwrvgnd_1
XTAP_TAPCELL_ROW_56_573 VSS VDD sky130_fd_sc_hd__tapvpwrvgnd_1
XTAP_TAPCELL_ROW_56_574 VSS VDD sky130_fd_sc_hd__tapvpwrvgnd_1
XTAP_TAPCELL_ROW_56_575 VSS VDD sky130_fd_sc_hd__tapvpwrvgnd_1
XTAP_TAPCELL_ROW_56_576 VSS VDD sky130_fd_sc_hd__tapvpwrvgnd_1
XTAP_TAPCELL_ROW_56_577 VSS VDD sky130_fd_sc_hd__tapvpwrvgnd_1
XTAP_TAPCELL_ROW_56_578 VSS VDD sky130_fd_sc_hd__tapvpwrvgnd_1
XTAP_TAPCELL_ROW_56_579 VSS VDD sky130_fd_sc_hd__tapvpwrvgnd_1
XTAP_TAPCELL_ROW_57_580 VSS VDD sky130_fd_sc_hd__tapvpwrvgnd_1
XTAP_TAPCELL_ROW_57_581 VSS VDD sky130_fd_sc_hd__tapvpwrvgnd_1
XTAP_TAPCELL_ROW_57_582 VSS VDD sky130_fd_sc_hd__tapvpwrvgnd_1
XTAP_TAPCELL_ROW_57_583 VSS VDD sky130_fd_sc_hd__tapvpwrvgnd_1
XTAP_TAPCELL_ROW_57_584 VSS VDD sky130_fd_sc_hd__tapvpwrvgnd_1
XTAP_TAPCELL_ROW_57_585 VSS VDD sky130_fd_sc_hd__tapvpwrvgnd_1
XTAP_TAPCELL_ROW_57_586 VSS VDD sky130_fd_sc_hd__tapvpwrvgnd_1
XTAP_TAPCELL_ROW_57_587 VSS VDD sky130_fd_sc_hd__tapvpwrvgnd_1
XTAP_TAPCELL_ROW_57_588 VSS VDD sky130_fd_sc_hd__tapvpwrvgnd_1
XTAP_TAPCELL_ROW_57_589 VSS VDD sky130_fd_sc_hd__tapvpwrvgnd_1
XTAP_TAPCELL_ROW_58_590 VSS VDD sky130_fd_sc_hd__tapvpwrvgnd_1
XTAP_TAPCELL_ROW_58_591 VSS VDD sky130_fd_sc_hd__tapvpwrvgnd_1
XTAP_TAPCELL_ROW_58_592 VSS VDD sky130_fd_sc_hd__tapvpwrvgnd_1
XTAP_TAPCELL_ROW_58_593 VSS VDD sky130_fd_sc_hd__tapvpwrvgnd_1
XTAP_TAPCELL_ROW_58_594 VSS VDD sky130_fd_sc_hd__tapvpwrvgnd_1
XTAP_TAPCELL_ROW_58_595 VSS VDD sky130_fd_sc_hd__tapvpwrvgnd_1
XTAP_TAPCELL_ROW_58_596 VSS VDD sky130_fd_sc_hd__tapvpwrvgnd_1
XTAP_TAPCELL_ROW_58_597 VSS VDD sky130_fd_sc_hd__tapvpwrvgnd_1
XTAP_TAPCELL_ROW_58_598 VSS VDD sky130_fd_sc_hd__tapvpwrvgnd_1
XTAP_TAPCELL_ROW_58_599 VSS VDD sky130_fd_sc_hd__tapvpwrvgnd_1
XTAP_TAPCELL_ROW_59_600 VSS VDD sky130_fd_sc_hd__tapvpwrvgnd_1
XTAP_TAPCELL_ROW_59_601 VSS VDD sky130_fd_sc_hd__tapvpwrvgnd_1
XTAP_TAPCELL_ROW_59_602 VSS VDD sky130_fd_sc_hd__tapvpwrvgnd_1
XTAP_TAPCELL_ROW_59_603 VSS VDD sky130_fd_sc_hd__tapvpwrvgnd_1
XTAP_TAPCELL_ROW_59_604 VSS VDD sky130_fd_sc_hd__tapvpwrvgnd_1
XTAP_TAPCELL_ROW_59_605 VSS VDD sky130_fd_sc_hd__tapvpwrvgnd_1
XTAP_TAPCELL_ROW_59_606 VSS VDD sky130_fd_sc_hd__tapvpwrvgnd_1
XTAP_TAPCELL_ROW_59_607 VSS VDD sky130_fd_sc_hd__tapvpwrvgnd_1
XTAP_TAPCELL_ROW_59_608 VSS VDD sky130_fd_sc_hd__tapvpwrvgnd_1
XTAP_TAPCELL_ROW_59_609 VSS VDD sky130_fd_sc_hd__tapvpwrvgnd_1
XTAP_TAPCELL_ROW_60_610 VSS VDD sky130_fd_sc_hd__tapvpwrvgnd_1
XTAP_TAPCELL_ROW_60_611 VSS VDD sky130_fd_sc_hd__tapvpwrvgnd_1
XTAP_TAPCELL_ROW_60_612 VSS VDD sky130_fd_sc_hd__tapvpwrvgnd_1
XTAP_TAPCELL_ROW_60_613 VSS VDD sky130_fd_sc_hd__tapvpwrvgnd_1
XTAP_TAPCELL_ROW_60_614 VSS VDD sky130_fd_sc_hd__tapvpwrvgnd_1
XTAP_TAPCELL_ROW_60_615 VSS VDD sky130_fd_sc_hd__tapvpwrvgnd_1
XTAP_TAPCELL_ROW_60_616 VSS VDD sky130_fd_sc_hd__tapvpwrvgnd_1
XTAP_TAPCELL_ROW_60_617 VSS VDD sky130_fd_sc_hd__tapvpwrvgnd_1
XTAP_TAPCELL_ROW_60_618 VSS VDD sky130_fd_sc_hd__tapvpwrvgnd_1
XTAP_TAPCELL_ROW_60_619 VSS VDD sky130_fd_sc_hd__tapvpwrvgnd_1
XTAP_TAPCELL_ROW_61_620 VSS VDD sky130_fd_sc_hd__tapvpwrvgnd_1
XTAP_TAPCELL_ROW_61_621 VSS VDD sky130_fd_sc_hd__tapvpwrvgnd_1
XTAP_TAPCELL_ROW_61_622 VSS VDD sky130_fd_sc_hd__tapvpwrvgnd_1
XTAP_TAPCELL_ROW_61_623 VSS VDD sky130_fd_sc_hd__tapvpwrvgnd_1
XTAP_TAPCELL_ROW_61_624 VSS VDD sky130_fd_sc_hd__tapvpwrvgnd_1
XTAP_TAPCELL_ROW_61_625 VSS VDD sky130_fd_sc_hd__tapvpwrvgnd_1
XTAP_TAPCELL_ROW_61_626 VSS VDD sky130_fd_sc_hd__tapvpwrvgnd_1
XTAP_TAPCELL_ROW_61_627 VSS VDD sky130_fd_sc_hd__tapvpwrvgnd_1
XTAP_TAPCELL_ROW_61_628 VSS VDD sky130_fd_sc_hd__tapvpwrvgnd_1
XTAP_TAPCELL_ROW_61_629 VSS VDD sky130_fd_sc_hd__tapvpwrvgnd_1
XTAP_TAPCELL_ROW_62_630 VSS VDD sky130_fd_sc_hd__tapvpwrvgnd_1
XTAP_TAPCELL_ROW_62_631 VSS VDD sky130_fd_sc_hd__tapvpwrvgnd_1
XTAP_TAPCELL_ROW_62_632 VSS VDD sky130_fd_sc_hd__tapvpwrvgnd_1
XTAP_TAPCELL_ROW_62_633 VSS VDD sky130_fd_sc_hd__tapvpwrvgnd_1
XTAP_TAPCELL_ROW_62_634 VSS VDD sky130_fd_sc_hd__tapvpwrvgnd_1
XTAP_TAPCELL_ROW_62_635 VSS VDD sky130_fd_sc_hd__tapvpwrvgnd_1
XTAP_TAPCELL_ROW_62_636 VSS VDD sky130_fd_sc_hd__tapvpwrvgnd_1
XTAP_TAPCELL_ROW_62_637 VSS VDD sky130_fd_sc_hd__tapvpwrvgnd_1
XTAP_TAPCELL_ROW_62_638 VSS VDD sky130_fd_sc_hd__tapvpwrvgnd_1
XTAP_TAPCELL_ROW_62_639 VSS VDD sky130_fd_sc_hd__tapvpwrvgnd_1
XTAP_TAPCELL_ROW_63_640 VSS VDD sky130_fd_sc_hd__tapvpwrvgnd_1
XTAP_TAPCELL_ROW_63_641 VSS VDD sky130_fd_sc_hd__tapvpwrvgnd_1
XTAP_TAPCELL_ROW_63_642 VSS VDD sky130_fd_sc_hd__tapvpwrvgnd_1
XTAP_TAPCELL_ROW_63_643 VSS VDD sky130_fd_sc_hd__tapvpwrvgnd_1
XTAP_TAPCELL_ROW_63_644 VSS VDD sky130_fd_sc_hd__tapvpwrvgnd_1
XTAP_TAPCELL_ROW_63_645 VSS VDD sky130_fd_sc_hd__tapvpwrvgnd_1
XTAP_TAPCELL_ROW_63_646 VSS VDD sky130_fd_sc_hd__tapvpwrvgnd_1
XTAP_TAPCELL_ROW_63_647 VSS VDD sky130_fd_sc_hd__tapvpwrvgnd_1
XTAP_TAPCELL_ROW_63_648 VSS VDD sky130_fd_sc_hd__tapvpwrvgnd_1
XTAP_TAPCELL_ROW_63_649 VSS VDD sky130_fd_sc_hd__tapvpwrvgnd_1
XTAP_TAPCELL_ROW_64_650 VSS VDD sky130_fd_sc_hd__tapvpwrvgnd_1
XTAP_TAPCELL_ROW_64_651 VSS VDD sky130_fd_sc_hd__tapvpwrvgnd_1
XTAP_TAPCELL_ROW_64_652 VSS VDD sky130_fd_sc_hd__tapvpwrvgnd_1
XTAP_TAPCELL_ROW_64_653 VSS VDD sky130_fd_sc_hd__tapvpwrvgnd_1
XTAP_TAPCELL_ROW_64_654 VSS VDD sky130_fd_sc_hd__tapvpwrvgnd_1
XTAP_TAPCELL_ROW_64_655 VSS VDD sky130_fd_sc_hd__tapvpwrvgnd_1
XTAP_TAPCELL_ROW_64_656 VSS VDD sky130_fd_sc_hd__tapvpwrvgnd_1
XTAP_TAPCELL_ROW_64_657 VSS VDD sky130_fd_sc_hd__tapvpwrvgnd_1
XTAP_TAPCELL_ROW_64_658 VSS VDD sky130_fd_sc_hd__tapvpwrvgnd_1
XTAP_TAPCELL_ROW_64_659 VSS VDD sky130_fd_sc_hd__tapvpwrvgnd_1
XTAP_TAPCELL_ROW_65_660 VSS VDD sky130_fd_sc_hd__tapvpwrvgnd_1
XTAP_TAPCELL_ROW_65_661 VSS VDD sky130_fd_sc_hd__tapvpwrvgnd_1
XTAP_TAPCELL_ROW_65_662 VSS VDD sky130_fd_sc_hd__tapvpwrvgnd_1
XTAP_TAPCELL_ROW_65_663 VSS VDD sky130_fd_sc_hd__tapvpwrvgnd_1
XTAP_TAPCELL_ROW_65_664 VSS VDD sky130_fd_sc_hd__tapvpwrvgnd_1
XTAP_TAPCELL_ROW_65_665 VSS VDD sky130_fd_sc_hd__tapvpwrvgnd_1
XTAP_TAPCELL_ROW_65_666 VSS VDD sky130_fd_sc_hd__tapvpwrvgnd_1
XTAP_TAPCELL_ROW_65_667 VSS VDD sky130_fd_sc_hd__tapvpwrvgnd_1
XTAP_TAPCELL_ROW_65_668 VSS VDD sky130_fd_sc_hd__tapvpwrvgnd_1
XTAP_TAPCELL_ROW_65_669 VSS VDD sky130_fd_sc_hd__tapvpwrvgnd_1
XTAP_TAPCELL_ROW_66_670 VSS VDD sky130_fd_sc_hd__tapvpwrvgnd_1
XTAP_TAPCELL_ROW_66_671 VSS VDD sky130_fd_sc_hd__tapvpwrvgnd_1
XTAP_TAPCELL_ROW_66_672 VSS VDD sky130_fd_sc_hd__tapvpwrvgnd_1
XTAP_TAPCELL_ROW_66_673 VSS VDD sky130_fd_sc_hd__tapvpwrvgnd_1
XTAP_TAPCELL_ROW_66_674 VSS VDD sky130_fd_sc_hd__tapvpwrvgnd_1
XTAP_TAPCELL_ROW_66_675 VSS VDD sky130_fd_sc_hd__tapvpwrvgnd_1
XTAP_TAPCELL_ROW_66_676 VSS VDD sky130_fd_sc_hd__tapvpwrvgnd_1
XTAP_TAPCELL_ROW_66_677 VSS VDD sky130_fd_sc_hd__tapvpwrvgnd_1
XTAP_TAPCELL_ROW_66_678 VSS VDD sky130_fd_sc_hd__tapvpwrvgnd_1
XTAP_TAPCELL_ROW_66_679 VSS VDD sky130_fd_sc_hd__tapvpwrvgnd_1
XTAP_TAPCELL_ROW_67_680 VSS VDD sky130_fd_sc_hd__tapvpwrvgnd_1
XTAP_TAPCELL_ROW_67_681 VSS VDD sky130_fd_sc_hd__tapvpwrvgnd_1
XTAP_TAPCELL_ROW_67_682 VSS VDD sky130_fd_sc_hd__tapvpwrvgnd_1
XTAP_TAPCELL_ROW_67_683 VSS VDD sky130_fd_sc_hd__tapvpwrvgnd_1
XTAP_TAPCELL_ROW_67_684 VSS VDD sky130_fd_sc_hd__tapvpwrvgnd_1
XTAP_TAPCELL_ROW_67_685 VSS VDD sky130_fd_sc_hd__tapvpwrvgnd_1
XTAP_TAPCELL_ROW_67_686 VSS VDD sky130_fd_sc_hd__tapvpwrvgnd_1
XTAP_TAPCELL_ROW_67_687 VSS VDD sky130_fd_sc_hd__tapvpwrvgnd_1
XTAP_TAPCELL_ROW_67_688 VSS VDD sky130_fd_sc_hd__tapvpwrvgnd_1
XTAP_TAPCELL_ROW_67_689 VSS VDD sky130_fd_sc_hd__tapvpwrvgnd_1
XTAP_TAPCELL_ROW_68_690 VSS VDD sky130_fd_sc_hd__tapvpwrvgnd_1
XTAP_TAPCELL_ROW_68_691 VSS VDD sky130_fd_sc_hd__tapvpwrvgnd_1
XTAP_TAPCELL_ROW_68_692 VSS VDD sky130_fd_sc_hd__tapvpwrvgnd_1
XTAP_TAPCELL_ROW_68_693 VSS VDD sky130_fd_sc_hd__tapvpwrvgnd_1
XTAP_TAPCELL_ROW_68_694 VSS VDD sky130_fd_sc_hd__tapvpwrvgnd_1
XTAP_TAPCELL_ROW_68_695 VSS VDD sky130_fd_sc_hd__tapvpwrvgnd_1
XTAP_TAPCELL_ROW_68_696 VSS VDD sky130_fd_sc_hd__tapvpwrvgnd_1
XTAP_TAPCELL_ROW_68_697 VSS VDD sky130_fd_sc_hd__tapvpwrvgnd_1
XTAP_TAPCELL_ROW_68_698 VSS VDD sky130_fd_sc_hd__tapvpwrvgnd_1
XTAP_TAPCELL_ROW_68_699 VSS VDD sky130_fd_sc_hd__tapvpwrvgnd_1
XTAP_TAPCELL_ROW_69_700 VSS VDD sky130_fd_sc_hd__tapvpwrvgnd_1
XTAP_TAPCELL_ROW_69_701 VSS VDD sky130_fd_sc_hd__tapvpwrvgnd_1
XTAP_TAPCELL_ROW_69_702 VSS VDD sky130_fd_sc_hd__tapvpwrvgnd_1
XTAP_TAPCELL_ROW_69_703 VSS VDD sky130_fd_sc_hd__tapvpwrvgnd_1
XTAP_TAPCELL_ROW_69_704 VSS VDD sky130_fd_sc_hd__tapvpwrvgnd_1
XTAP_TAPCELL_ROW_69_705 VSS VDD sky130_fd_sc_hd__tapvpwrvgnd_1
XTAP_TAPCELL_ROW_69_706 VSS VDD sky130_fd_sc_hd__tapvpwrvgnd_1
XTAP_TAPCELL_ROW_69_707 VSS VDD sky130_fd_sc_hd__tapvpwrvgnd_1
XTAP_TAPCELL_ROW_69_708 VSS VDD sky130_fd_sc_hd__tapvpwrvgnd_1
XTAP_TAPCELL_ROW_69_709 VSS VDD sky130_fd_sc_hd__tapvpwrvgnd_1
XTAP_TAPCELL_ROW_70_710 VSS VDD sky130_fd_sc_hd__tapvpwrvgnd_1
XTAP_TAPCELL_ROW_70_711 VSS VDD sky130_fd_sc_hd__tapvpwrvgnd_1
XTAP_TAPCELL_ROW_70_712 VSS VDD sky130_fd_sc_hd__tapvpwrvgnd_1
XTAP_TAPCELL_ROW_70_713 VSS VDD sky130_fd_sc_hd__tapvpwrvgnd_1
XTAP_TAPCELL_ROW_70_714 VSS VDD sky130_fd_sc_hd__tapvpwrvgnd_1
XTAP_TAPCELL_ROW_70_715 VSS VDD sky130_fd_sc_hd__tapvpwrvgnd_1
XTAP_TAPCELL_ROW_70_716 VSS VDD sky130_fd_sc_hd__tapvpwrvgnd_1
XTAP_TAPCELL_ROW_70_717 VSS VDD sky130_fd_sc_hd__tapvpwrvgnd_1
XTAP_TAPCELL_ROW_70_718 VSS VDD sky130_fd_sc_hd__tapvpwrvgnd_1
XTAP_TAPCELL_ROW_70_719 VSS VDD sky130_fd_sc_hd__tapvpwrvgnd_1
XTAP_TAPCELL_ROW_71_720 VSS VDD sky130_fd_sc_hd__tapvpwrvgnd_1
XTAP_TAPCELL_ROW_71_721 VSS VDD sky130_fd_sc_hd__tapvpwrvgnd_1
XTAP_TAPCELL_ROW_71_722 VSS VDD sky130_fd_sc_hd__tapvpwrvgnd_1
XTAP_TAPCELL_ROW_71_723 VSS VDD sky130_fd_sc_hd__tapvpwrvgnd_1
XTAP_TAPCELL_ROW_71_724 VSS VDD sky130_fd_sc_hd__tapvpwrvgnd_1
XTAP_TAPCELL_ROW_71_725 VSS VDD sky130_fd_sc_hd__tapvpwrvgnd_1
XTAP_TAPCELL_ROW_71_726 VSS VDD sky130_fd_sc_hd__tapvpwrvgnd_1
XTAP_TAPCELL_ROW_71_727 VSS VDD sky130_fd_sc_hd__tapvpwrvgnd_1
XTAP_TAPCELL_ROW_71_728 VSS VDD sky130_fd_sc_hd__tapvpwrvgnd_1
XTAP_TAPCELL_ROW_71_729 VSS VDD sky130_fd_sc_hd__tapvpwrvgnd_1
XTAP_TAPCELL_ROW_72_730 VSS VDD sky130_fd_sc_hd__tapvpwrvgnd_1
XTAP_TAPCELL_ROW_72_731 VSS VDD sky130_fd_sc_hd__tapvpwrvgnd_1
XTAP_TAPCELL_ROW_72_732 VSS VDD sky130_fd_sc_hd__tapvpwrvgnd_1
XTAP_TAPCELL_ROW_72_733 VSS VDD sky130_fd_sc_hd__tapvpwrvgnd_1
XTAP_TAPCELL_ROW_72_734 VSS VDD sky130_fd_sc_hd__tapvpwrvgnd_1
XTAP_TAPCELL_ROW_72_735 VSS VDD sky130_fd_sc_hd__tapvpwrvgnd_1
XTAP_TAPCELL_ROW_72_736 VSS VDD sky130_fd_sc_hd__tapvpwrvgnd_1
XTAP_TAPCELL_ROW_72_737 VSS VDD sky130_fd_sc_hd__tapvpwrvgnd_1
XTAP_TAPCELL_ROW_72_738 VSS VDD sky130_fd_sc_hd__tapvpwrvgnd_1
XTAP_TAPCELL_ROW_72_739 VSS VDD sky130_fd_sc_hd__tapvpwrvgnd_1
XTAP_TAPCELL_ROW_73_740 VSS VDD sky130_fd_sc_hd__tapvpwrvgnd_1
XTAP_TAPCELL_ROW_73_741 VSS VDD sky130_fd_sc_hd__tapvpwrvgnd_1
XTAP_TAPCELL_ROW_73_742 VSS VDD sky130_fd_sc_hd__tapvpwrvgnd_1
XTAP_TAPCELL_ROW_73_743 VSS VDD sky130_fd_sc_hd__tapvpwrvgnd_1
XTAP_TAPCELL_ROW_73_744 VSS VDD sky130_fd_sc_hd__tapvpwrvgnd_1
XTAP_TAPCELL_ROW_73_745 VSS VDD sky130_fd_sc_hd__tapvpwrvgnd_1
XTAP_TAPCELL_ROW_73_746 VSS VDD sky130_fd_sc_hd__tapvpwrvgnd_1
XTAP_TAPCELL_ROW_73_747 VSS VDD sky130_fd_sc_hd__tapvpwrvgnd_1
XTAP_TAPCELL_ROW_73_748 VSS VDD sky130_fd_sc_hd__tapvpwrvgnd_1
XTAP_TAPCELL_ROW_73_749 VSS VDD sky130_fd_sc_hd__tapvpwrvgnd_1
XTAP_TAPCELL_ROW_74_750 VSS VDD sky130_fd_sc_hd__tapvpwrvgnd_1
XTAP_TAPCELL_ROW_74_751 VSS VDD sky130_fd_sc_hd__tapvpwrvgnd_1
XTAP_TAPCELL_ROW_74_752 VSS VDD sky130_fd_sc_hd__tapvpwrvgnd_1
XTAP_TAPCELL_ROW_74_753 VSS VDD sky130_fd_sc_hd__tapvpwrvgnd_1
XTAP_TAPCELL_ROW_74_754 VSS VDD sky130_fd_sc_hd__tapvpwrvgnd_1
XTAP_TAPCELL_ROW_74_755 VSS VDD sky130_fd_sc_hd__tapvpwrvgnd_1
XTAP_TAPCELL_ROW_74_756 VSS VDD sky130_fd_sc_hd__tapvpwrvgnd_1
XTAP_TAPCELL_ROW_74_757 VSS VDD sky130_fd_sc_hd__tapvpwrvgnd_1
XTAP_TAPCELL_ROW_74_758 VSS VDD sky130_fd_sc_hd__tapvpwrvgnd_1
XTAP_TAPCELL_ROW_74_759 VSS VDD sky130_fd_sc_hd__tapvpwrvgnd_1
XTAP_TAPCELL_ROW_75_760 VSS VDD sky130_fd_sc_hd__tapvpwrvgnd_1
XTAP_TAPCELL_ROW_75_761 VSS VDD sky130_fd_sc_hd__tapvpwrvgnd_1
XTAP_TAPCELL_ROW_75_762 VSS VDD sky130_fd_sc_hd__tapvpwrvgnd_1
XTAP_TAPCELL_ROW_75_763 VSS VDD sky130_fd_sc_hd__tapvpwrvgnd_1
XTAP_TAPCELL_ROW_75_764 VSS VDD sky130_fd_sc_hd__tapvpwrvgnd_1
XTAP_TAPCELL_ROW_75_765 VSS VDD sky130_fd_sc_hd__tapvpwrvgnd_1
XTAP_TAPCELL_ROW_75_766 VSS VDD sky130_fd_sc_hd__tapvpwrvgnd_1
XTAP_TAPCELL_ROW_75_767 VSS VDD sky130_fd_sc_hd__tapvpwrvgnd_1
XTAP_TAPCELL_ROW_75_768 VSS VDD sky130_fd_sc_hd__tapvpwrvgnd_1
XTAP_TAPCELL_ROW_75_769 VSS VDD sky130_fd_sc_hd__tapvpwrvgnd_1
XTAP_TAPCELL_ROW_76_770 VSS VDD sky130_fd_sc_hd__tapvpwrvgnd_1
XTAP_TAPCELL_ROW_76_771 VSS VDD sky130_fd_sc_hd__tapvpwrvgnd_1
XTAP_TAPCELL_ROW_76_772 VSS VDD sky130_fd_sc_hd__tapvpwrvgnd_1
XTAP_TAPCELL_ROW_76_773 VSS VDD sky130_fd_sc_hd__tapvpwrvgnd_1
XTAP_TAPCELL_ROW_76_774 VSS VDD sky130_fd_sc_hd__tapvpwrvgnd_1
XTAP_TAPCELL_ROW_76_775 VSS VDD sky130_fd_sc_hd__tapvpwrvgnd_1
XTAP_TAPCELL_ROW_76_776 VSS VDD sky130_fd_sc_hd__tapvpwrvgnd_1
XTAP_TAPCELL_ROW_76_777 VSS VDD sky130_fd_sc_hd__tapvpwrvgnd_1
XTAP_TAPCELL_ROW_76_778 VSS VDD sky130_fd_sc_hd__tapvpwrvgnd_1
XTAP_TAPCELL_ROW_76_779 VSS VDD sky130_fd_sc_hd__tapvpwrvgnd_1
XTAP_TAPCELL_ROW_77_780 VSS VDD sky130_fd_sc_hd__tapvpwrvgnd_1
XTAP_TAPCELL_ROW_77_781 VSS VDD sky130_fd_sc_hd__tapvpwrvgnd_1
XTAP_TAPCELL_ROW_77_782 VSS VDD sky130_fd_sc_hd__tapvpwrvgnd_1
XTAP_TAPCELL_ROW_77_783 VSS VDD sky130_fd_sc_hd__tapvpwrvgnd_1
XTAP_TAPCELL_ROW_77_784 VSS VDD sky130_fd_sc_hd__tapvpwrvgnd_1
XTAP_TAPCELL_ROW_77_785 VSS VDD sky130_fd_sc_hd__tapvpwrvgnd_1
XTAP_TAPCELL_ROW_77_786 VSS VDD sky130_fd_sc_hd__tapvpwrvgnd_1
XTAP_TAPCELL_ROW_77_787 VSS VDD sky130_fd_sc_hd__tapvpwrvgnd_1
XTAP_TAPCELL_ROW_77_788 VSS VDD sky130_fd_sc_hd__tapvpwrvgnd_1
XTAP_TAPCELL_ROW_77_789 VSS VDD sky130_fd_sc_hd__tapvpwrvgnd_1
XTAP_TAPCELL_ROW_78_790 VSS VDD sky130_fd_sc_hd__tapvpwrvgnd_1
XTAP_TAPCELL_ROW_78_791 VSS VDD sky130_fd_sc_hd__tapvpwrvgnd_1
XTAP_TAPCELL_ROW_78_792 VSS VDD sky130_fd_sc_hd__tapvpwrvgnd_1
XTAP_TAPCELL_ROW_78_793 VSS VDD sky130_fd_sc_hd__tapvpwrvgnd_1
XTAP_TAPCELL_ROW_78_794 VSS VDD sky130_fd_sc_hd__tapvpwrvgnd_1
XTAP_TAPCELL_ROW_78_795 VSS VDD sky130_fd_sc_hd__tapvpwrvgnd_1
XTAP_TAPCELL_ROW_78_796 VSS VDD sky130_fd_sc_hd__tapvpwrvgnd_1
XTAP_TAPCELL_ROW_78_797 VSS VDD sky130_fd_sc_hd__tapvpwrvgnd_1
XTAP_TAPCELL_ROW_78_798 VSS VDD sky130_fd_sc_hd__tapvpwrvgnd_1
XTAP_TAPCELL_ROW_78_799 VSS VDD sky130_fd_sc_hd__tapvpwrvgnd_1
XTAP_TAPCELL_ROW_79_800 VSS VDD sky130_fd_sc_hd__tapvpwrvgnd_1
XTAP_TAPCELL_ROW_79_801 VSS VDD sky130_fd_sc_hd__tapvpwrvgnd_1
XTAP_TAPCELL_ROW_79_802 VSS VDD sky130_fd_sc_hd__tapvpwrvgnd_1
XTAP_TAPCELL_ROW_79_803 VSS VDD sky130_fd_sc_hd__tapvpwrvgnd_1
XTAP_TAPCELL_ROW_79_804 VSS VDD sky130_fd_sc_hd__tapvpwrvgnd_1
XTAP_TAPCELL_ROW_79_805 VSS VDD sky130_fd_sc_hd__tapvpwrvgnd_1
XTAP_TAPCELL_ROW_79_806 VSS VDD sky130_fd_sc_hd__tapvpwrvgnd_1
XTAP_TAPCELL_ROW_79_807 VSS VDD sky130_fd_sc_hd__tapvpwrvgnd_1
XTAP_TAPCELL_ROW_79_808 VSS VDD sky130_fd_sc_hd__tapvpwrvgnd_1
XTAP_TAPCELL_ROW_79_809 VSS VDD sky130_fd_sc_hd__tapvpwrvgnd_1
XTAP_TAPCELL_ROW_80_810 VSS VDD sky130_fd_sc_hd__tapvpwrvgnd_1
XTAP_TAPCELL_ROW_80_811 VSS VDD sky130_fd_sc_hd__tapvpwrvgnd_1
XTAP_TAPCELL_ROW_80_812 VSS VDD sky130_fd_sc_hd__tapvpwrvgnd_1
XTAP_TAPCELL_ROW_80_813 VSS VDD sky130_fd_sc_hd__tapvpwrvgnd_1
XTAP_TAPCELL_ROW_80_814 VSS VDD sky130_fd_sc_hd__tapvpwrvgnd_1
XTAP_TAPCELL_ROW_80_815 VSS VDD sky130_fd_sc_hd__tapvpwrvgnd_1
XTAP_TAPCELL_ROW_80_816 VSS VDD sky130_fd_sc_hd__tapvpwrvgnd_1
XTAP_TAPCELL_ROW_80_817 VSS VDD sky130_fd_sc_hd__tapvpwrvgnd_1
XTAP_TAPCELL_ROW_80_818 VSS VDD sky130_fd_sc_hd__tapvpwrvgnd_1
XTAP_TAPCELL_ROW_80_819 VSS VDD sky130_fd_sc_hd__tapvpwrvgnd_1
XTAP_TAPCELL_ROW_81_820 VSS VDD sky130_fd_sc_hd__tapvpwrvgnd_1
XTAP_TAPCELL_ROW_81_821 VSS VDD sky130_fd_sc_hd__tapvpwrvgnd_1
XTAP_TAPCELL_ROW_81_822 VSS VDD sky130_fd_sc_hd__tapvpwrvgnd_1
XTAP_TAPCELL_ROW_81_823 VSS VDD sky130_fd_sc_hd__tapvpwrvgnd_1
XTAP_TAPCELL_ROW_81_824 VSS VDD sky130_fd_sc_hd__tapvpwrvgnd_1
XTAP_TAPCELL_ROW_81_825 VSS VDD sky130_fd_sc_hd__tapvpwrvgnd_1
XTAP_TAPCELL_ROW_81_826 VSS VDD sky130_fd_sc_hd__tapvpwrvgnd_1
XTAP_TAPCELL_ROW_81_827 VSS VDD sky130_fd_sc_hd__tapvpwrvgnd_1
XTAP_TAPCELL_ROW_81_828 VSS VDD sky130_fd_sc_hd__tapvpwrvgnd_1
XTAP_TAPCELL_ROW_81_829 VSS VDD sky130_fd_sc_hd__tapvpwrvgnd_1
XTAP_TAPCELL_ROW_82_830 VSS VDD sky130_fd_sc_hd__tapvpwrvgnd_1
XTAP_TAPCELL_ROW_82_831 VSS VDD sky130_fd_sc_hd__tapvpwrvgnd_1
XTAP_TAPCELL_ROW_82_832 VSS VDD sky130_fd_sc_hd__tapvpwrvgnd_1
XTAP_TAPCELL_ROW_82_833 VSS VDD sky130_fd_sc_hd__tapvpwrvgnd_1
XTAP_TAPCELL_ROW_82_834 VSS VDD sky130_fd_sc_hd__tapvpwrvgnd_1
XTAP_TAPCELL_ROW_82_835 VSS VDD sky130_fd_sc_hd__tapvpwrvgnd_1
XTAP_TAPCELL_ROW_82_836 VSS VDD sky130_fd_sc_hd__tapvpwrvgnd_1
XTAP_TAPCELL_ROW_82_837 VSS VDD sky130_fd_sc_hd__tapvpwrvgnd_1
XTAP_TAPCELL_ROW_82_838 VSS VDD sky130_fd_sc_hd__tapvpwrvgnd_1
XTAP_TAPCELL_ROW_82_839 VSS VDD sky130_fd_sc_hd__tapvpwrvgnd_1
XTAP_TAPCELL_ROW_83_840 VSS VDD sky130_fd_sc_hd__tapvpwrvgnd_1
XTAP_TAPCELL_ROW_83_841 VSS VDD sky130_fd_sc_hd__tapvpwrvgnd_1
XTAP_TAPCELL_ROW_83_842 VSS VDD sky130_fd_sc_hd__tapvpwrvgnd_1
XTAP_TAPCELL_ROW_83_843 VSS VDD sky130_fd_sc_hd__tapvpwrvgnd_1
XTAP_TAPCELL_ROW_83_844 VSS VDD sky130_fd_sc_hd__tapvpwrvgnd_1
XTAP_TAPCELL_ROW_83_845 VSS VDD sky130_fd_sc_hd__tapvpwrvgnd_1
XTAP_TAPCELL_ROW_83_846 VSS VDD sky130_fd_sc_hd__tapvpwrvgnd_1
XTAP_TAPCELL_ROW_83_847 VSS VDD sky130_fd_sc_hd__tapvpwrvgnd_1
XTAP_TAPCELL_ROW_83_848 VSS VDD sky130_fd_sc_hd__tapvpwrvgnd_1
XTAP_TAPCELL_ROW_83_849 VSS VDD sky130_fd_sc_hd__tapvpwrvgnd_1
XTAP_TAPCELL_ROW_84_850 VSS VDD sky130_fd_sc_hd__tapvpwrvgnd_1
XTAP_TAPCELL_ROW_84_851 VSS VDD sky130_fd_sc_hd__tapvpwrvgnd_1
XTAP_TAPCELL_ROW_84_852 VSS VDD sky130_fd_sc_hd__tapvpwrvgnd_1
XTAP_TAPCELL_ROW_84_853 VSS VDD sky130_fd_sc_hd__tapvpwrvgnd_1
XTAP_TAPCELL_ROW_84_854 VSS VDD sky130_fd_sc_hd__tapvpwrvgnd_1
XTAP_TAPCELL_ROW_84_855 VSS VDD sky130_fd_sc_hd__tapvpwrvgnd_1
XTAP_TAPCELL_ROW_84_856 VSS VDD sky130_fd_sc_hd__tapvpwrvgnd_1
XTAP_TAPCELL_ROW_84_857 VSS VDD sky130_fd_sc_hd__tapvpwrvgnd_1
XTAP_TAPCELL_ROW_84_858 VSS VDD sky130_fd_sc_hd__tapvpwrvgnd_1
XTAP_TAPCELL_ROW_84_859 VSS VDD sky130_fd_sc_hd__tapvpwrvgnd_1
XTAP_TAPCELL_ROW_85_860 VSS VDD sky130_fd_sc_hd__tapvpwrvgnd_1
XTAP_TAPCELL_ROW_85_861 VSS VDD sky130_fd_sc_hd__tapvpwrvgnd_1
XTAP_TAPCELL_ROW_85_862 VSS VDD sky130_fd_sc_hd__tapvpwrvgnd_1
XTAP_TAPCELL_ROW_85_863 VSS VDD sky130_fd_sc_hd__tapvpwrvgnd_1
XTAP_TAPCELL_ROW_85_864 VSS VDD sky130_fd_sc_hd__tapvpwrvgnd_1
XTAP_TAPCELL_ROW_85_865 VSS VDD sky130_fd_sc_hd__tapvpwrvgnd_1
XTAP_TAPCELL_ROW_85_866 VSS VDD sky130_fd_sc_hd__tapvpwrvgnd_1
XTAP_TAPCELL_ROW_85_867 VSS VDD sky130_fd_sc_hd__tapvpwrvgnd_1
XTAP_TAPCELL_ROW_85_868 VSS VDD sky130_fd_sc_hd__tapvpwrvgnd_1
XTAP_TAPCELL_ROW_85_869 VSS VDD sky130_fd_sc_hd__tapvpwrvgnd_1
XTAP_TAPCELL_ROW_86_870 VSS VDD sky130_fd_sc_hd__tapvpwrvgnd_1
XTAP_TAPCELL_ROW_86_871 VSS VDD sky130_fd_sc_hd__tapvpwrvgnd_1
XTAP_TAPCELL_ROW_86_872 VSS VDD sky130_fd_sc_hd__tapvpwrvgnd_1
XTAP_TAPCELL_ROW_86_873 VSS VDD sky130_fd_sc_hd__tapvpwrvgnd_1
XTAP_TAPCELL_ROW_86_874 VSS VDD sky130_fd_sc_hd__tapvpwrvgnd_1
XTAP_TAPCELL_ROW_86_875 VSS VDD sky130_fd_sc_hd__tapvpwrvgnd_1
XTAP_TAPCELL_ROW_86_876 VSS VDD sky130_fd_sc_hd__tapvpwrvgnd_1
XTAP_TAPCELL_ROW_86_877 VSS VDD sky130_fd_sc_hd__tapvpwrvgnd_1
XTAP_TAPCELL_ROW_86_878 VSS VDD sky130_fd_sc_hd__tapvpwrvgnd_1
XTAP_TAPCELL_ROW_86_879 VSS VDD sky130_fd_sc_hd__tapvpwrvgnd_1
XTAP_TAPCELL_ROW_87_880 VSS VDD sky130_fd_sc_hd__tapvpwrvgnd_1
XTAP_TAPCELL_ROW_87_881 VSS VDD sky130_fd_sc_hd__tapvpwrvgnd_1
XTAP_TAPCELL_ROW_87_882 VSS VDD sky130_fd_sc_hd__tapvpwrvgnd_1
XTAP_TAPCELL_ROW_87_883 VSS VDD sky130_fd_sc_hd__tapvpwrvgnd_1
XTAP_TAPCELL_ROW_87_884 VSS VDD sky130_fd_sc_hd__tapvpwrvgnd_1
XTAP_TAPCELL_ROW_87_885 VSS VDD sky130_fd_sc_hd__tapvpwrvgnd_1
XTAP_TAPCELL_ROW_87_886 VSS VDD sky130_fd_sc_hd__tapvpwrvgnd_1
XTAP_TAPCELL_ROW_87_887 VSS VDD sky130_fd_sc_hd__tapvpwrvgnd_1
XTAP_TAPCELL_ROW_87_888 VSS VDD sky130_fd_sc_hd__tapvpwrvgnd_1
XTAP_TAPCELL_ROW_87_889 VSS VDD sky130_fd_sc_hd__tapvpwrvgnd_1
XTAP_TAPCELL_ROW_88_890 VSS VDD sky130_fd_sc_hd__tapvpwrvgnd_1
XTAP_TAPCELL_ROW_88_891 VSS VDD sky130_fd_sc_hd__tapvpwrvgnd_1
XTAP_TAPCELL_ROW_88_892 VSS VDD sky130_fd_sc_hd__tapvpwrvgnd_1
XTAP_TAPCELL_ROW_88_893 VSS VDD sky130_fd_sc_hd__tapvpwrvgnd_1
XTAP_TAPCELL_ROW_88_894 VSS VDD sky130_fd_sc_hd__tapvpwrvgnd_1
XTAP_TAPCELL_ROW_88_895 VSS VDD sky130_fd_sc_hd__tapvpwrvgnd_1
XTAP_TAPCELL_ROW_88_896 VSS VDD sky130_fd_sc_hd__tapvpwrvgnd_1
XTAP_TAPCELL_ROW_88_897 VSS VDD sky130_fd_sc_hd__tapvpwrvgnd_1
XTAP_TAPCELL_ROW_88_898 VSS VDD sky130_fd_sc_hd__tapvpwrvgnd_1
XTAP_TAPCELL_ROW_88_899 VSS VDD sky130_fd_sc_hd__tapvpwrvgnd_1
XTAP_TAPCELL_ROW_89_900 VSS VDD sky130_fd_sc_hd__tapvpwrvgnd_1
XTAP_TAPCELL_ROW_89_901 VSS VDD sky130_fd_sc_hd__tapvpwrvgnd_1
XTAP_TAPCELL_ROW_89_902 VSS VDD sky130_fd_sc_hd__tapvpwrvgnd_1
XTAP_TAPCELL_ROW_89_903 VSS VDD sky130_fd_sc_hd__tapvpwrvgnd_1
XTAP_TAPCELL_ROW_89_904 VSS VDD sky130_fd_sc_hd__tapvpwrvgnd_1
XTAP_TAPCELL_ROW_89_905 VSS VDD sky130_fd_sc_hd__tapvpwrvgnd_1
XTAP_TAPCELL_ROW_89_906 VSS VDD sky130_fd_sc_hd__tapvpwrvgnd_1
XTAP_TAPCELL_ROW_89_907 VSS VDD sky130_fd_sc_hd__tapvpwrvgnd_1
XTAP_TAPCELL_ROW_89_908 VSS VDD sky130_fd_sc_hd__tapvpwrvgnd_1
XTAP_TAPCELL_ROW_89_909 VSS VDD sky130_fd_sc_hd__tapvpwrvgnd_1
XTAP_TAPCELL_ROW_90_910 VSS VDD sky130_fd_sc_hd__tapvpwrvgnd_1
XTAP_TAPCELL_ROW_90_911 VSS VDD sky130_fd_sc_hd__tapvpwrvgnd_1
XTAP_TAPCELL_ROW_90_912 VSS VDD sky130_fd_sc_hd__tapvpwrvgnd_1
XTAP_TAPCELL_ROW_90_913 VSS VDD sky130_fd_sc_hd__tapvpwrvgnd_1
XTAP_TAPCELL_ROW_90_914 VSS VDD sky130_fd_sc_hd__tapvpwrvgnd_1
XTAP_TAPCELL_ROW_90_915 VSS VDD sky130_fd_sc_hd__tapvpwrvgnd_1
XTAP_TAPCELL_ROW_90_916 VSS VDD sky130_fd_sc_hd__tapvpwrvgnd_1
XTAP_TAPCELL_ROW_90_917 VSS VDD sky130_fd_sc_hd__tapvpwrvgnd_1
XTAP_TAPCELL_ROW_90_918 VSS VDD sky130_fd_sc_hd__tapvpwrvgnd_1
XTAP_TAPCELL_ROW_90_919 VSS VDD sky130_fd_sc_hd__tapvpwrvgnd_1
XTAP_TAPCELL_ROW_91_920 VSS VDD sky130_fd_sc_hd__tapvpwrvgnd_1
XTAP_TAPCELL_ROW_91_921 VSS VDD sky130_fd_sc_hd__tapvpwrvgnd_1
XTAP_TAPCELL_ROW_91_922 VSS VDD sky130_fd_sc_hd__tapvpwrvgnd_1
XTAP_TAPCELL_ROW_91_923 VSS VDD sky130_fd_sc_hd__tapvpwrvgnd_1
XTAP_TAPCELL_ROW_91_924 VSS VDD sky130_fd_sc_hd__tapvpwrvgnd_1
XTAP_TAPCELL_ROW_91_925 VSS VDD sky130_fd_sc_hd__tapvpwrvgnd_1
XTAP_TAPCELL_ROW_91_926 VSS VDD sky130_fd_sc_hd__tapvpwrvgnd_1
XTAP_TAPCELL_ROW_91_927 VSS VDD sky130_fd_sc_hd__tapvpwrvgnd_1
XTAP_TAPCELL_ROW_91_928 VSS VDD sky130_fd_sc_hd__tapvpwrvgnd_1
XTAP_TAPCELL_ROW_91_929 VSS VDD sky130_fd_sc_hd__tapvpwrvgnd_1
XTAP_TAPCELL_ROW_92_930 VSS VDD sky130_fd_sc_hd__tapvpwrvgnd_1
XTAP_TAPCELL_ROW_92_931 VSS VDD sky130_fd_sc_hd__tapvpwrvgnd_1
XTAP_TAPCELL_ROW_92_932 VSS VDD sky130_fd_sc_hd__tapvpwrvgnd_1
XTAP_TAPCELL_ROW_92_933 VSS VDD sky130_fd_sc_hd__tapvpwrvgnd_1
XTAP_TAPCELL_ROW_92_934 VSS VDD sky130_fd_sc_hd__tapvpwrvgnd_1
XTAP_TAPCELL_ROW_92_935 VSS VDD sky130_fd_sc_hd__tapvpwrvgnd_1
XTAP_TAPCELL_ROW_92_936 VSS VDD sky130_fd_sc_hd__tapvpwrvgnd_1
XTAP_TAPCELL_ROW_92_937 VSS VDD sky130_fd_sc_hd__tapvpwrvgnd_1
XTAP_TAPCELL_ROW_92_938 VSS VDD sky130_fd_sc_hd__tapvpwrvgnd_1
XTAP_TAPCELL_ROW_92_939 VSS VDD sky130_fd_sc_hd__tapvpwrvgnd_1
XTAP_TAPCELL_ROW_93_940 VSS VDD sky130_fd_sc_hd__tapvpwrvgnd_1
XTAP_TAPCELL_ROW_93_941 VSS VDD sky130_fd_sc_hd__tapvpwrvgnd_1
XTAP_TAPCELL_ROW_93_942 VSS VDD sky130_fd_sc_hd__tapvpwrvgnd_1
XTAP_TAPCELL_ROW_93_943 VSS VDD sky130_fd_sc_hd__tapvpwrvgnd_1
XTAP_TAPCELL_ROW_93_944 VSS VDD sky130_fd_sc_hd__tapvpwrvgnd_1
XTAP_TAPCELL_ROW_93_945 VSS VDD sky130_fd_sc_hd__tapvpwrvgnd_1
XTAP_TAPCELL_ROW_93_946 VSS VDD sky130_fd_sc_hd__tapvpwrvgnd_1
XTAP_TAPCELL_ROW_93_947 VSS VDD sky130_fd_sc_hd__tapvpwrvgnd_1
XTAP_TAPCELL_ROW_93_948 VSS VDD sky130_fd_sc_hd__tapvpwrvgnd_1
XTAP_TAPCELL_ROW_93_949 VSS VDD sky130_fd_sc_hd__tapvpwrvgnd_1
XTAP_TAPCELL_ROW_94_950 VSS VDD sky130_fd_sc_hd__tapvpwrvgnd_1
XTAP_TAPCELL_ROW_94_951 VSS VDD sky130_fd_sc_hd__tapvpwrvgnd_1
XTAP_TAPCELL_ROW_94_952 VSS VDD sky130_fd_sc_hd__tapvpwrvgnd_1
XTAP_TAPCELL_ROW_94_953 VSS VDD sky130_fd_sc_hd__tapvpwrvgnd_1
XTAP_TAPCELL_ROW_94_954 VSS VDD sky130_fd_sc_hd__tapvpwrvgnd_1
XTAP_TAPCELL_ROW_94_955 VSS VDD sky130_fd_sc_hd__tapvpwrvgnd_1
XTAP_TAPCELL_ROW_94_956 VSS VDD sky130_fd_sc_hd__tapvpwrvgnd_1
XTAP_TAPCELL_ROW_94_957 VSS VDD sky130_fd_sc_hd__tapvpwrvgnd_1
XTAP_TAPCELL_ROW_94_958 VSS VDD sky130_fd_sc_hd__tapvpwrvgnd_1
XTAP_TAPCELL_ROW_94_959 VSS VDD sky130_fd_sc_hd__tapvpwrvgnd_1
XTAP_TAPCELL_ROW_95_960 VSS VDD sky130_fd_sc_hd__tapvpwrvgnd_1
XTAP_TAPCELL_ROW_95_961 VSS VDD sky130_fd_sc_hd__tapvpwrvgnd_1
XTAP_TAPCELL_ROW_95_962 VSS VDD sky130_fd_sc_hd__tapvpwrvgnd_1
XTAP_TAPCELL_ROW_95_963 VSS VDD sky130_fd_sc_hd__tapvpwrvgnd_1
XTAP_TAPCELL_ROW_95_964 VSS VDD sky130_fd_sc_hd__tapvpwrvgnd_1
XTAP_TAPCELL_ROW_95_965 VSS VDD sky130_fd_sc_hd__tapvpwrvgnd_1
XTAP_TAPCELL_ROW_95_966 VSS VDD sky130_fd_sc_hd__tapvpwrvgnd_1
XTAP_TAPCELL_ROW_95_967 VSS VDD sky130_fd_sc_hd__tapvpwrvgnd_1
XTAP_TAPCELL_ROW_95_968 VSS VDD sky130_fd_sc_hd__tapvpwrvgnd_1
XTAP_TAPCELL_ROW_95_969 VSS VDD sky130_fd_sc_hd__tapvpwrvgnd_1
XTAP_TAPCELL_ROW_96_970 VSS VDD sky130_fd_sc_hd__tapvpwrvgnd_1
XTAP_TAPCELL_ROW_96_971 VSS VDD sky130_fd_sc_hd__tapvpwrvgnd_1
XTAP_TAPCELL_ROW_96_972 VSS VDD sky130_fd_sc_hd__tapvpwrvgnd_1
XTAP_TAPCELL_ROW_96_973 VSS VDD sky130_fd_sc_hd__tapvpwrvgnd_1
XTAP_TAPCELL_ROW_96_974 VSS VDD sky130_fd_sc_hd__tapvpwrvgnd_1
XTAP_TAPCELL_ROW_96_975 VSS VDD sky130_fd_sc_hd__tapvpwrvgnd_1
XTAP_TAPCELL_ROW_96_976 VSS VDD sky130_fd_sc_hd__tapvpwrvgnd_1
XTAP_TAPCELL_ROW_96_977 VSS VDD sky130_fd_sc_hd__tapvpwrvgnd_1
XTAP_TAPCELL_ROW_96_978 VSS VDD sky130_fd_sc_hd__tapvpwrvgnd_1
XTAP_TAPCELL_ROW_96_979 VSS VDD sky130_fd_sc_hd__tapvpwrvgnd_1
XTAP_TAPCELL_ROW_97_980 VSS VDD sky130_fd_sc_hd__tapvpwrvgnd_1
XTAP_TAPCELL_ROW_97_981 VSS VDD sky130_fd_sc_hd__tapvpwrvgnd_1
XTAP_TAPCELL_ROW_97_982 VSS VDD sky130_fd_sc_hd__tapvpwrvgnd_1
XTAP_TAPCELL_ROW_97_983 VSS VDD sky130_fd_sc_hd__tapvpwrvgnd_1
XTAP_TAPCELL_ROW_97_984 VSS VDD sky130_fd_sc_hd__tapvpwrvgnd_1
XTAP_TAPCELL_ROW_97_985 VSS VDD sky130_fd_sc_hd__tapvpwrvgnd_1
XTAP_TAPCELL_ROW_97_986 VSS VDD sky130_fd_sc_hd__tapvpwrvgnd_1
XTAP_TAPCELL_ROW_97_987 VSS VDD sky130_fd_sc_hd__tapvpwrvgnd_1
XTAP_TAPCELL_ROW_97_988 VSS VDD sky130_fd_sc_hd__tapvpwrvgnd_1
XTAP_TAPCELL_ROW_97_989 VSS VDD sky130_fd_sc_hd__tapvpwrvgnd_1
XTAP_TAPCELL_ROW_98_990 VSS VDD sky130_fd_sc_hd__tapvpwrvgnd_1
XTAP_TAPCELL_ROW_98_991 VSS VDD sky130_fd_sc_hd__tapvpwrvgnd_1
XTAP_TAPCELL_ROW_98_992 VSS VDD sky130_fd_sc_hd__tapvpwrvgnd_1
XTAP_TAPCELL_ROW_98_993 VSS VDD sky130_fd_sc_hd__tapvpwrvgnd_1
XTAP_TAPCELL_ROW_98_994 VSS VDD sky130_fd_sc_hd__tapvpwrvgnd_1
XTAP_TAPCELL_ROW_98_995 VSS VDD sky130_fd_sc_hd__tapvpwrvgnd_1
XTAP_TAPCELL_ROW_98_996 VSS VDD sky130_fd_sc_hd__tapvpwrvgnd_1
XTAP_TAPCELL_ROW_98_997 VSS VDD sky130_fd_sc_hd__tapvpwrvgnd_1
XTAP_TAPCELL_ROW_98_998 VSS VDD sky130_fd_sc_hd__tapvpwrvgnd_1
XTAP_TAPCELL_ROW_98_999 VSS VDD sky130_fd_sc_hd__tapvpwrvgnd_1
XTAP_TAPCELL_ROW_99_1000 VSS VDD sky130_fd_sc_hd__tapvpwrvgnd_1
XTAP_TAPCELL_ROW_99_1001 VSS VDD sky130_fd_sc_hd__tapvpwrvgnd_1
XTAP_TAPCELL_ROW_99_1002 VSS VDD sky130_fd_sc_hd__tapvpwrvgnd_1
XTAP_TAPCELL_ROW_99_1003 VSS VDD sky130_fd_sc_hd__tapvpwrvgnd_1
XTAP_TAPCELL_ROW_99_1004 VSS VDD sky130_fd_sc_hd__tapvpwrvgnd_1
XTAP_TAPCELL_ROW_99_1005 VSS VDD sky130_fd_sc_hd__tapvpwrvgnd_1
XTAP_TAPCELL_ROW_99_1006 VSS VDD sky130_fd_sc_hd__tapvpwrvgnd_1
XTAP_TAPCELL_ROW_99_1007 VSS VDD sky130_fd_sc_hd__tapvpwrvgnd_1
XTAP_TAPCELL_ROW_99_1008 VSS VDD sky130_fd_sc_hd__tapvpwrvgnd_1
XTAP_TAPCELL_ROW_99_1009 VSS VDD sky130_fd_sc_hd__tapvpwrvgnd_1
XTAP_TAPCELL_ROW_100_1010 VSS VDD sky130_fd_sc_hd__tapvpwrvgnd_1
XTAP_TAPCELL_ROW_100_1011 VSS VDD sky130_fd_sc_hd__tapvpwrvgnd_1
XTAP_TAPCELL_ROW_100_1012 VSS VDD sky130_fd_sc_hd__tapvpwrvgnd_1
XTAP_TAPCELL_ROW_100_1013 VSS VDD sky130_fd_sc_hd__tapvpwrvgnd_1
XTAP_TAPCELL_ROW_100_1014 VSS VDD sky130_fd_sc_hd__tapvpwrvgnd_1
XTAP_TAPCELL_ROW_100_1015 VSS VDD sky130_fd_sc_hd__tapvpwrvgnd_1
XTAP_TAPCELL_ROW_100_1016 VSS VDD sky130_fd_sc_hd__tapvpwrvgnd_1
XTAP_TAPCELL_ROW_100_1017 VSS VDD sky130_fd_sc_hd__tapvpwrvgnd_1
XTAP_TAPCELL_ROW_100_1018 VSS VDD sky130_fd_sc_hd__tapvpwrvgnd_1
XTAP_TAPCELL_ROW_100_1019 VSS VDD sky130_fd_sc_hd__tapvpwrvgnd_1
XTAP_TAPCELL_ROW_101_1020 VSS VDD sky130_fd_sc_hd__tapvpwrvgnd_1
XTAP_TAPCELL_ROW_101_1021 VSS VDD sky130_fd_sc_hd__tapvpwrvgnd_1
XTAP_TAPCELL_ROW_101_1022 VSS VDD sky130_fd_sc_hd__tapvpwrvgnd_1
XTAP_TAPCELL_ROW_101_1023 VSS VDD sky130_fd_sc_hd__tapvpwrvgnd_1
XTAP_TAPCELL_ROW_101_1024 VSS VDD sky130_fd_sc_hd__tapvpwrvgnd_1
XTAP_TAPCELL_ROW_101_1025 VSS VDD sky130_fd_sc_hd__tapvpwrvgnd_1
XTAP_TAPCELL_ROW_101_1026 VSS VDD sky130_fd_sc_hd__tapvpwrvgnd_1
XTAP_TAPCELL_ROW_101_1027 VSS VDD sky130_fd_sc_hd__tapvpwrvgnd_1
XTAP_TAPCELL_ROW_101_1028 VSS VDD sky130_fd_sc_hd__tapvpwrvgnd_1
XTAP_TAPCELL_ROW_101_1029 VSS VDD sky130_fd_sc_hd__tapvpwrvgnd_1
XTAP_TAPCELL_ROW_102_1030 VSS VDD sky130_fd_sc_hd__tapvpwrvgnd_1
XTAP_TAPCELL_ROW_102_1031 VSS VDD sky130_fd_sc_hd__tapvpwrvgnd_1
XTAP_TAPCELL_ROW_102_1032 VSS VDD sky130_fd_sc_hd__tapvpwrvgnd_1
XTAP_TAPCELL_ROW_102_1033 VSS VDD sky130_fd_sc_hd__tapvpwrvgnd_1
XTAP_TAPCELL_ROW_102_1034 VSS VDD sky130_fd_sc_hd__tapvpwrvgnd_1
XTAP_TAPCELL_ROW_102_1035 VSS VDD sky130_fd_sc_hd__tapvpwrvgnd_1
XTAP_TAPCELL_ROW_102_1036 VSS VDD sky130_fd_sc_hd__tapvpwrvgnd_1
XTAP_TAPCELL_ROW_102_1037 VSS VDD sky130_fd_sc_hd__tapvpwrvgnd_1
XTAP_TAPCELL_ROW_102_1038 VSS VDD sky130_fd_sc_hd__tapvpwrvgnd_1
XTAP_TAPCELL_ROW_102_1039 VSS VDD sky130_fd_sc_hd__tapvpwrvgnd_1
XTAP_TAPCELL_ROW_103_1040 VSS VDD sky130_fd_sc_hd__tapvpwrvgnd_1
XTAP_TAPCELL_ROW_103_1041 VSS VDD sky130_fd_sc_hd__tapvpwrvgnd_1
XTAP_TAPCELL_ROW_103_1042 VSS VDD sky130_fd_sc_hd__tapvpwrvgnd_1
XTAP_TAPCELL_ROW_103_1043 VSS VDD sky130_fd_sc_hd__tapvpwrvgnd_1
XTAP_TAPCELL_ROW_103_1044 VSS VDD sky130_fd_sc_hd__tapvpwrvgnd_1
XTAP_TAPCELL_ROW_103_1045 VSS VDD sky130_fd_sc_hd__tapvpwrvgnd_1
XTAP_TAPCELL_ROW_103_1046 VSS VDD sky130_fd_sc_hd__tapvpwrvgnd_1
XTAP_TAPCELL_ROW_103_1047 VSS VDD sky130_fd_sc_hd__tapvpwrvgnd_1
XTAP_TAPCELL_ROW_103_1048 VSS VDD sky130_fd_sc_hd__tapvpwrvgnd_1
XTAP_TAPCELL_ROW_103_1049 VSS VDD sky130_fd_sc_hd__tapvpwrvgnd_1
XTAP_TAPCELL_ROW_104_1050 VSS VDD sky130_fd_sc_hd__tapvpwrvgnd_1
XTAP_TAPCELL_ROW_104_1051 VSS VDD sky130_fd_sc_hd__tapvpwrvgnd_1
XTAP_TAPCELL_ROW_104_1052 VSS VDD sky130_fd_sc_hd__tapvpwrvgnd_1
XTAP_TAPCELL_ROW_104_1053 VSS VDD sky130_fd_sc_hd__tapvpwrvgnd_1
XTAP_TAPCELL_ROW_104_1054 VSS VDD sky130_fd_sc_hd__tapvpwrvgnd_1
XTAP_TAPCELL_ROW_104_1055 VSS VDD sky130_fd_sc_hd__tapvpwrvgnd_1
XTAP_TAPCELL_ROW_104_1056 VSS VDD sky130_fd_sc_hd__tapvpwrvgnd_1
XTAP_TAPCELL_ROW_104_1057 VSS VDD sky130_fd_sc_hd__tapvpwrvgnd_1
XTAP_TAPCELL_ROW_104_1058 VSS VDD sky130_fd_sc_hd__tapvpwrvgnd_1
XTAP_TAPCELL_ROW_104_1059 VSS VDD sky130_fd_sc_hd__tapvpwrvgnd_1
XTAP_TAPCELL_ROW_105_1060 VSS VDD sky130_fd_sc_hd__tapvpwrvgnd_1
XTAP_TAPCELL_ROW_105_1061 VSS VDD sky130_fd_sc_hd__tapvpwrvgnd_1
XTAP_TAPCELL_ROW_105_1062 VSS VDD sky130_fd_sc_hd__tapvpwrvgnd_1
XTAP_TAPCELL_ROW_105_1063 VSS VDD sky130_fd_sc_hd__tapvpwrvgnd_1
XTAP_TAPCELL_ROW_105_1064 VSS VDD sky130_fd_sc_hd__tapvpwrvgnd_1
XTAP_TAPCELL_ROW_105_1065 VSS VDD sky130_fd_sc_hd__tapvpwrvgnd_1
XTAP_TAPCELL_ROW_105_1066 VSS VDD sky130_fd_sc_hd__tapvpwrvgnd_1
XTAP_TAPCELL_ROW_105_1067 VSS VDD sky130_fd_sc_hd__tapvpwrvgnd_1
XTAP_TAPCELL_ROW_105_1068 VSS VDD sky130_fd_sc_hd__tapvpwrvgnd_1
XTAP_TAPCELL_ROW_105_1069 VSS VDD sky130_fd_sc_hd__tapvpwrvgnd_1
XTAP_TAPCELL_ROW_105_1070 VSS VDD sky130_fd_sc_hd__tapvpwrvgnd_1
XTAP_TAPCELL_ROW_105_1071 VSS VDD sky130_fd_sc_hd__tapvpwrvgnd_1
XTAP_TAPCELL_ROW_105_1072 VSS VDD sky130_fd_sc_hd__tapvpwrvgnd_1
XTAP_TAPCELL_ROW_105_1073 VSS VDD sky130_fd_sc_hd__tapvpwrvgnd_1
XTAP_TAPCELL_ROW_105_1074 VSS VDD sky130_fd_sc_hd__tapvpwrvgnd_1
XTAP_TAPCELL_ROW_105_1075 VSS VDD sky130_fd_sc_hd__tapvpwrvgnd_1
XTAP_TAPCELL_ROW_105_1076 VSS VDD sky130_fd_sc_hd__tapvpwrvgnd_1
XTAP_TAPCELL_ROW_105_1077 VSS VDD sky130_fd_sc_hd__tapvpwrvgnd_1
XTAP_TAPCELL_ROW_105_1078 VSS VDD sky130_fd_sc_hd__tapvpwrvgnd_1
XTAP_TAPCELL_ROW_105_1079 VSS VDD sky130_fd_sc_hd__tapvpwrvgnd_1
Xinput143 in_flat[84] VSS VSS VDD VDD net142 sky130_fd_sc_hd__clkdlybuf4s50_1
Xinput144 in_flat[85] VSS VSS VDD VDD net143 sky130_fd_sc_hd__clkdlybuf4s50_1
Xinput145 in_flat[86] VSS VSS VDD VDD net144 sky130_fd_sc_hd__clkdlybuf4s50_1
Xinput146 in_flat[87] VSS VSS VDD VDD net145 sky130_fd_sc_hd__clkdlybuf4s50_1
Xinput147 in_flat[88] VSS VSS VDD VDD net146 sky130_fd_sc_hd__clkdlybuf4s50_1
Xinput148 in_flat[89] VSS VSS VDD VDD net147 sky130_fd_sc_hd__clkdlybuf4s50_1
Xinput149 in_flat[8] VSS VSS VDD VDD net148 sky130_fd_sc_hd__clkdlybuf4s50_1
Xinput150 in_flat[90] VSS VSS VDD VDD net149 sky130_fd_sc_hd__clkdlybuf4s50_1
Xinput151 in_flat[91] VSS VSS VDD VDD net150 sky130_fd_sc_hd__clkdlybuf4s50_1
Xinput152 in_flat[92] VSS VSS VDD VDD net151 sky130_fd_sc_hd__clkdlybuf4s50_1
Xinput153 in_flat[93] VSS VSS VDD VDD net152 sky130_fd_sc_hd__clkdlybuf4s50_1
Xinput154 in_flat[94] VSS VSS VDD VDD net153 sky130_fd_sc_hd__clkdlybuf4s50_1
Xinput155 in_flat[95] VSS VSS VDD VDD net154 sky130_fd_sc_hd__clkdlybuf4s50_1
Xinput156 in_flat[96] VSS VSS VDD VDD net155 sky130_fd_sc_hd__clkdlybuf4s50_1
Xinput157 in_flat[97] VSS VSS VDD VDD net156 sky130_fd_sc_hd__clkdlybuf4s50_1
Xinput158 in_flat[98] VSS VSS VDD VDD net157 sky130_fd_sc_hd__clkdlybuf4s50_1
Xinput159 in_flat[99] VSS VSS VDD VDD net158 sky130_fd_sc_hd__clkdlybuf4s50_1
Xinput160 in_flat[9] VSS VSS VDD VDD net159 sky130_fd_sc_hd__clkdlybuf4s50_1
Xinput161 in_valid VSS VSS VDD VDD net160 sky130_fd_sc_hd__clkdlybuf4s50_1
Xinput162 rst_n VSS VSS VDD VDD net161 sky130_fd_sc_hd__buf_8
Xoutput163 net162 VSS VSS VDD VDD out_flat[0] sky130_fd_sc_hd__clkdlybuf4s50_1
Xoutput164 net163 VSS VSS VDD VDD out_flat[10] sky130_fd_sc_hd__clkdlybuf4s50_1
Xoutput165 net164 VSS VSS VDD VDD out_flat[112] sky130_fd_sc_hd__clkdlybuf4s50_1
Xoutput166 net165 VSS VSS VDD VDD out_flat[113] sky130_fd_sc_hd__clkdlybuf4s50_1
Xoutput167 net166 VSS VSS VDD VDD out_flat[114] sky130_fd_sc_hd__clkdlybuf4s50_1
Xoutput168 net167 VSS VSS VDD VDD out_flat[115] sky130_fd_sc_hd__clkdlybuf4s50_1
Xoutput169 net168 VSS VSS VDD VDD out_flat[116] sky130_fd_sc_hd__clkdlybuf4s50_1
Xoutput170 net169 VSS VSS VDD VDD out_flat[117] sky130_fd_sc_hd__clkdlybuf4s50_1
Xoutput171 net170 VSS VSS VDD VDD out_flat[118] sky130_fd_sc_hd__clkdlybuf4s50_1
Xoutput172 net171 VSS VSS VDD VDD out_flat[119] sky130_fd_sc_hd__clkdlybuf4s50_1
Xoutput173 net172 VSS VSS VDD VDD out_flat[11] sky130_fd_sc_hd__clkdlybuf4s50_1
Xoutput174 net173 VSS VSS VDD VDD out_flat[120] sky130_fd_sc_hd__clkdlybuf4s50_1
Xoutput175 net174 VSS VSS VDD VDD out_flat[121] sky130_fd_sc_hd__clkdlybuf4s50_1
Xoutput176 net175 VSS VSS VDD VDD out_flat[122] sky130_fd_sc_hd__clkdlybuf4s50_1
Xoutput177 net176 VSS VSS VDD VDD out_flat[123] sky130_fd_sc_hd__clkdlybuf4s50_1
Xoutput178 net177 VSS VSS VDD VDD out_flat[124] sky130_fd_sc_hd__clkdlybuf4s50_1
Xoutput179 net178 VSS VSS VDD VDD out_flat[125] sky130_fd_sc_hd__clkdlybuf4s50_1
Xoutput180 net179 VSS VSS VDD VDD out_flat[126] sky130_fd_sc_hd__clkdlybuf4s50_1
Xoutput181 net180 VSS VSS VDD VDD out_flat[127] sky130_fd_sc_hd__clkdlybuf4s50_1
Xoutput182 net181 VSS VSS VDD VDD out_flat[128] sky130_fd_sc_hd__clkdlybuf4s50_1
Xoutput183 net182 VSS VSS VDD VDD out_flat[129] sky130_fd_sc_hd__clkdlybuf4s50_1
Xoutput184 net183 VSS VSS VDD VDD out_flat[12] sky130_fd_sc_hd__clkdlybuf4s50_1
Xoutput185 net184 VSS VSS VDD VDD out_flat[130] sky130_fd_sc_hd__clkdlybuf4s50_1
Xoutput186 net185 VSS VSS VDD VDD out_flat[131] sky130_fd_sc_hd__clkdlybuf4s50_1
Xoutput187 net186 VSS VSS VDD VDD out_flat[132] sky130_fd_sc_hd__clkdlybuf4s50_1
Xoutput188 net187 VSS VSS VDD VDD out_flat[133] sky130_fd_sc_hd__clkdlybuf4s50_1
Xoutput189 net188 VSS VSS VDD VDD out_flat[134] sky130_fd_sc_hd__clkdlybuf4s50_1
Xoutput190 net189 VSS VSS VDD VDD out_flat[135] sky130_fd_sc_hd__clkdlybuf4s50_1
Xoutput191 net190 VSS VSS VDD VDD out_flat[136] sky130_fd_sc_hd__clkdlybuf4s50_1
Xoutput192 net191 VSS VSS VDD VDD out_flat[137] sky130_fd_sc_hd__clkdlybuf4s50_1
Xoutput193 net192 VSS VSS VDD VDD out_flat[138] sky130_fd_sc_hd__clkdlybuf4s50_1
Xoutput194 net193 VSS VSS VDD VDD out_flat[139] sky130_fd_sc_hd__clkdlybuf4s50_1
Xoutput195 net194 VSS VSS VDD VDD out_flat[13] sky130_fd_sc_hd__clkdlybuf4s50_1
Xoutput196 net195 VSS VSS VDD VDD out_flat[140] sky130_fd_sc_hd__clkdlybuf4s50_1
Xoutput197 net196 VSS VSS VDD VDD out_flat[141] sky130_fd_sc_hd__clkdlybuf4s50_1
Xoutput198 net197 VSS VSS VDD VDD out_flat[142] sky130_fd_sc_hd__clkdlybuf4s50_1
Xoutput199 net198 VSS VSS VDD VDD out_flat[143] sky130_fd_sc_hd__clkdlybuf4s50_1
Xoutput200 net199 VSS VSS VDD VDD out_flat[144] sky130_fd_sc_hd__clkdlybuf4s50_1
Xoutput201 net200 VSS VSS VDD VDD out_flat[145] sky130_fd_sc_hd__clkdlybuf4s50_1
Xoutput202 net201 VSS VSS VDD VDD out_flat[146] sky130_fd_sc_hd__clkdlybuf4s50_1
Xoutput203 net202 VSS VSS VDD VDD out_flat[147] sky130_fd_sc_hd__clkdlybuf4s50_1
Xoutput204 net203 VSS VSS VDD VDD out_flat[148] sky130_fd_sc_hd__clkdlybuf4s50_1
Xoutput205 net204 VSS VSS VDD VDD out_flat[149] sky130_fd_sc_hd__clkdlybuf4s50_1
Xoutput206 net205 VSS VSS VDD VDD out_flat[14] sky130_fd_sc_hd__clkdlybuf4s50_1
Xoutput207 net206 VSS VSS VDD VDD out_flat[150] sky130_fd_sc_hd__clkdlybuf4s50_1
Xoutput208 net207 VSS VSS VDD VDD out_flat[151] sky130_fd_sc_hd__clkdlybuf4s50_1
Xoutput209 net208 VSS VSS VDD VDD out_flat[152] sky130_fd_sc_hd__clkdlybuf4s50_1
Xoutput210 net209 VSS VSS VDD VDD out_flat[153] sky130_fd_sc_hd__clkdlybuf4s50_1
Xoutput211 net210 VSS VSS VDD VDD out_flat[154] sky130_fd_sc_hd__clkdlybuf4s50_1
Xoutput212 net211 VSS VSS VDD VDD out_flat[155] sky130_fd_sc_hd__clkdlybuf4s50_1
Xoutput213 net212 VSS VSS VDD VDD out_flat[156] sky130_fd_sc_hd__clkdlybuf4s50_1
Xoutput214 net213 VSS VSS VDD VDD out_flat[157] sky130_fd_sc_hd__clkdlybuf4s50_1
Xoutput215 net214 VSS VSS VDD VDD out_flat[158] sky130_fd_sc_hd__clkdlybuf4s50_1
Xoutput216 net215 VSS VSS VDD VDD out_flat[159] sky130_fd_sc_hd__clkdlybuf4s50_1
Xoutput217 net216 VSS VSS VDD VDD out_flat[15] sky130_fd_sc_hd__clkdlybuf4s50_1
Xoutput218 net217 VSS VSS VDD VDD out_flat[160] sky130_fd_sc_hd__clkdlybuf4s50_1
Xoutput219 net218 VSS VSS VDD VDD out_flat[161] sky130_fd_sc_hd__clkdlybuf4s50_1
Xoutput220 net219 VSS VSS VDD VDD out_flat[162] sky130_fd_sc_hd__clkdlybuf4s50_1
Xoutput221 net220 VSS VSS VDD VDD out_flat[163] sky130_fd_sc_hd__clkdlybuf4s50_1
Xoutput222 net221 VSS VSS VDD VDD out_flat[164] sky130_fd_sc_hd__clkdlybuf4s50_1
Xoutput223 net222 VSS VSS VDD VDD out_flat[165] sky130_fd_sc_hd__clkdlybuf4s50_1
Xoutput224 net223 VSS VSS VDD VDD out_flat[166] sky130_fd_sc_hd__clkdlybuf4s50_1
Xoutput225 net224 VSS VSS VDD VDD out_flat[167] sky130_fd_sc_hd__clkdlybuf4s50_1
Xoutput226 net225 VSS VSS VDD VDD out_flat[168] sky130_fd_sc_hd__clkdlybuf4s50_1
Xoutput227 net226 VSS VSS VDD VDD out_flat[169] sky130_fd_sc_hd__clkdlybuf4s50_1
Xoutput228 net227 VSS VSS VDD VDD out_flat[16] sky130_fd_sc_hd__clkdlybuf4s50_1
Xoutput229 net228 VSS VSS VDD VDD out_flat[170] sky130_fd_sc_hd__clkdlybuf4s50_1
Xoutput230 net229 VSS VSS VDD VDD out_flat[171] sky130_fd_sc_hd__clkdlybuf4s50_1
Xoutput231 net230 VSS VSS VDD VDD out_flat[172] sky130_fd_sc_hd__clkdlybuf4s50_1
Xoutput232 net231 VSS VSS VDD VDD out_flat[173] sky130_fd_sc_hd__clkdlybuf4s50_1
Xoutput233 net233 VSS VSS VDD VDD out_flat[174] sky130_fd_sc_hd__clkdlybuf4s50_1
Xoutput234 net233 VSS VSS VDD VDD out_flat[175] sky130_fd_sc_hd__clkdlybuf4s50_1
Xoutput235 net234 VSS VSS VDD VDD out_flat[176] sky130_fd_sc_hd__clkdlybuf4s50_1
Xoutput236 net235 VSS VSS VDD VDD out_flat[177] sky130_fd_sc_hd__clkdlybuf4s50_1
Xoutput237 net236 VSS VSS VDD VDD out_flat[178] sky130_fd_sc_hd__clkdlybuf4s50_1
Xoutput238 net237 VSS VSS VDD VDD out_flat[179] sky130_fd_sc_hd__clkdlybuf4s50_1
Xoutput239 net238 VSS VSS VDD VDD out_flat[17] sky130_fd_sc_hd__clkdlybuf4s50_1
Xoutput240 net239 VSS VSS VDD VDD out_flat[180] sky130_fd_sc_hd__clkdlybuf4s50_1
Xoutput241 net240 VSS VSS VDD VDD out_flat[181] sky130_fd_sc_hd__clkdlybuf4s50_1
Xoutput242 net241 VSS VSS VDD VDD out_flat[182] sky130_fd_sc_hd__clkdlybuf4s50_1
Xoutput243 net242 VSS VSS VDD VDD out_flat[183] sky130_fd_sc_hd__clkdlybuf4s50_1
Xoutput244 net243 VSS VSS VDD VDD out_flat[184] sky130_fd_sc_hd__clkdlybuf4s50_1
Xoutput245 net244 VSS VSS VDD VDD out_flat[185] sky130_fd_sc_hd__clkdlybuf4s50_1
Xoutput246 net245 VSS VSS VDD VDD out_flat[186] sky130_fd_sc_hd__clkdlybuf4s50_1
Xoutput247 net246 VSS VSS VDD VDD out_flat[187] sky130_fd_sc_hd__clkdlybuf4s50_1
Xoutput248 net247 VSS VSS VDD VDD out_flat[188] sky130_fd_sc_hd__clkdlybuf4s50_1
Xoutput249 net248 VSS VSS VDD VDD out_flat[189] sky130_fd_sc_hd__clkdlybuf4s50_1
Xoutput250 net249 VSS VSS VDD VDD out_flat[18] sky130_fd_sc_hd__clkdlybuf4s50_1
Xoutput251 net251 VSS VSS VDD VDD out_flat[190] sky130_fd_sc_hd__clkdlybuf4s50_1
Xoutput252 net251 VSS VSS VDD VDD out_flat[191] sky130_fd_sc_hd__clkdlybuf4s50_1
Xoutput253 net252 VSS VSS VDD VDD out_flat[192] sky130_fd_sc_hd__clkdlybuf4s50_1
Xoutput254 net253 VSS VSS VDD VDD out_flat[193] sky130_fd_sc_hd__clkdlybuf4s50_1
Xoutput255 net254 VSS VSS VDD VDD out_flat[194] sky130_fd_sc_hd__clkdlybuf4s50_1
Xoutput256 net255 VSS VSS VDD VDD out_flat[195] sky130_fd_sc_hd__clkdlybuf4s50_1
Xoutput257 net256 VSS VSS VDD VDD out_flat[196] sky130_fd_sc_hd__clkdlybuf4s50_1
Xoutput258 net257 VSS VSS VDD VDD out_flat[197] sky130_fd_sc_hd__clkdlybuf4s50_1
Xoutput259 net258 VSS VSS VDD VDD out_flat[198] sky130_fd_sc_hd__clkdlybuf4s50_1
Xoutput260 net259 VSS VSS VDD VDD out_flat[199] sky130_fd_sc_hd__clkdlybuf4s50_1
Xoutput261 net260 VSS VSS VDD VDD out_flat[19] sky130_fd_sc_hd__clkdlybuf4s50_1
Xoutput262 net261 VSS VSS VDD VDD out_flat[1] sky130_fd_sc_hd__clkdlybuf4s50_1
Xoutput263 net262 VSS VSS VDD VDD out_flat[200] sky130_fd_sc_hd__clkdlybuf4s50_1
Xoutput264 net263 VSS VSS VDD VDD out_flat[201] sky130_fd_sc_hd__clkdlybuf4s50_1
Xoutput265 net264 VSS VSS VDD VDD out_flat[202] sky130_fd_sc_hd__clkdlybuf4s50_1
Xoutput266 net265 VSS VSS VDD VDD out_flat[203] sky130_fd_sc_hd__clkdlybuf4s50_1
Xoutput267 net266 VSS VSS VDD VDD out_flat[204] sky130_fd_sc_hd__clkdlybuf4s50_1
Xoutput268 net267 VSS VSS VDD VDD out_flat[205] sky130_fd_sc_hd__clkdlybuf4s50_1
Xoutput269 net268 VSS VSS VDD VDD out_flat[206] sky130_fd_sc_hd__clkdlybuf4s50_1
Xoutput270 net269 VSS VSS VDD VDD out_flat[207] sky130_fd_sc_hd__clkdlybuf4s50_1
Xoutput271 net270 VSS VSS VDD VDD out_flat[208] sky130_fd_sc_hd__clkdlybuf4s50_1
Xoutput272 net271 VSS VSS VDD VDD out_flat[209] sky130_fd_sc_hd__clkdlybuf4s50_1
Xoutput273 net272 VSS VSS VDD VDD out_flat[20] sky130_fd_sc_hd__clkdlybuf4s50_1
Xoutput274 net273 VSS VSS VDD VDD out_flat[210] sky130_fd_sc_hd__clkdlybuf4s50_1
Xoutput275 net274 VSS VSS VDD VDD out_flat[211] sky130_fd_sc_hd__clkdlybuf4s50_1
Xoutput276 net275 VSS VSS VDD VDD out_flat[212] sky130_fd_sc_hd__clkdlybuf4s50_1
Xoutput277 net276 VSS VSS VDD VDD out_flat[213] sky130_fd_sc_hd__clkdlybuf4s50_1
Xoutput278 net277 VSS VSS VDD VDD out_flat[214] sky130_fd_sc_hd__clkdlybuf4s50_1
Xoutput279 net278 VSS VSS VDD VDD out_flat[215] sky130_fd_sc_hd__clkdlybuf4s50_1
Xoutput280 net279 VSS VSS VDD VDD out_flat[216] sky130_fd_sc_hd__clkdlybuf4s50_1
Xoutput281 net280 VSS VSS VDD VDD out_flat[217] sky130_fd_sc_hd__clkdlybuf4s50_1
Xoutput282 net281 VSS VSS VDD VDD out_flat[218] sky130_fd_sc_hd__clkdlybuf4s50_1
Xoutput283 net282 VSS VSS VDD VDD out_flat[219] sky130_fd_sc_hd__clkdlybuf4s50_1
Xoutput284 net283 VSS VSS VDD VDD out_flat[21] sky130_fd_sc_hd__clkdlybuf4s50_1
Xoutput285 net284 VSS VSS VDD VDD out_flat[220] sky130_fd_sc_hd__clkdlybuf4s50_1
Xoutput286 net285 VSS VSS VDD VDD out_flat[221] sky130_fd_sc_hd__clkdlybuf4s50_1
Xoutput287 net286 VSS VSS VDD VDD out_flat[222] sky130_fd_sc_hd__clkdlybuf4s50_1
Xoutput288 net287 VSS VSS VDD VDD out_flat[223] sky130_fd_sc_hd__clkdlybuf4s50_1
Xoutput289 net288 VSS VSS VDD VDD out_flat[22] sky130_fd_sc_hd__clkdlybuf4s50_1
Xoutput290 net289 VSS VSS VDD VDD out_flat[23] sky130_fd_sc_hd__clkdlybuf4s50_1
Xoutput291 net290 VSS VSS VDD VDD out_flat[240] sky130_fd_sc_hd__clkdlybuf4s50_1
Xoutput292 net291 VSS VSS VDD VDD out_flat[241] sky130_fd_sc_hd__clkdlybuf4s50_1
Xoutput293 net292 VSS VSS VDD VDD out_flat[242] sky130_fd_sc_hd__clkdlybuf4s50_1
Xoutput294 net293 VSS VSS VDD VDD out_flat[243] sky130_fd_sc_hd__clkdlybuf4s50_1
Xoutput295 net294 VSS VSS VDD VDD out_flat[244] sky130_fd_sc_hd__clkdlybuf4s50_1
Xoutput296 net295 VSS VSS VDD VDD out_flat[245] sky130_fd_sc_hd__clkdlybuf4s50_1
Xoutput297 net296 VSS VSS VDD VDD out_flat[246] sky130_fd_sc_hd__clkdlybuf4s50_1
Xoutput298 net297 VSS VSS VDD VDD out_flat[247] sky130_fd_sc_hd__clkdlybuf4s50_1
Xoutput299 net298 VSS VSS VDD VDD out_flat[248] sky130_fd_sc_hd__clkdlybuf4s50_1
Xoutput300 net299 VSS VSS VDD VDD out_flat[249] sky130_fd_sc_hd__clkdlybuf4s50_1
Xoutput301 net300 VSS VSS VDD VDD out_flat[24] sky130_fd_sc_hd__clkdlybuf4s50_1
Xoutput302 net301 VSS VSS VDD VDD out_flat[250] sky130_fd_sc_hd__clkdlybuf4s50_1
Xoutput303 net302 VSS VSS VDD VDD out_flat[251] sky130_fd_sc_hd__clkdlybuf4s50_1
Xoutput304 net303 VSS VSS VDD VDD out_flat[252] sky130_fd_sc_hd__clkdlybuf4s50_1
Xoutput305 net304 VSS VSS VDD VDD out_flat[253] sky130_fd_sc_hd__clkdlybuf4s50_1
Xoutput306 net305 VSS VSS VDD VDD out_flat[254] sky130_fd_sc_hd__clkdlybuf4s50_1
Xoutput307 net306 VSS VSS VDD VDD out_flat[255] sky130_fd_sc_hd__clkdlybuf4s50_1
Xoutput308 net307 VSS VSS VDD VDD out_flat[25] sky130_fd_sc_hd__clkdlybuf4s50_1
Xoutput309 net308 VSS VSS VDD VDD out_flat[26] sky130_fd_sc_hd__clkdlybuf4s50_1
Xoutput310 net309 VSS VSS VDD VDD out_flat[27] sky130_fd_sc_hd__clkdlybuf4s50_1
Xoutput311 net310 VSS VSS VDD VDD out_flat[28] sky130_fd_sc_hd__clkdlybuf4s50_1
Xoutput312 net311 VSS VSS VDD VDD out_flat[29] sky130_fd_sc_hd__clkdlybuf4s50_1
Xoutput313 net312 VSS VSS VDD VDD out_flat[2] sky130_fd_sc_hd__clkdlybuf4s50_1
Xoutput314 net313 VSS VSS VDD VDD out_flat[30] sky130_fd_sc_hd__clkdlybuf4s50_1
Xoutput315 net314 VSS VSS VDD VDD out_flat[31] sky130_fd_sc_hd__clkdlybuf4s50_1
Xoutput316 net315 VSS VSS VDD VDD out_flat[32] sky130_fd_sc_hd__clkdlybuf4s50_1
Xoutput317 net316 VSS VSS VDD VDD out_flat[33] sky130_fd_sc_hd__clkdlybuf4s50_1
Xoutput318 net317 VSS VSS VDD VDD out_flat[34] sky130_fd_sc_hd__clkdlybuf4s50_1
Xoutput319 net318 VSS VSS VDD VDD out_flat[35] sky130_fd_sc_hd__clkdlybuf4s50_1
Xoutput320 net319 VSS VSS VDD VDD out_flat[36] sky130_fd_sc_hd__clkdlybuf4s50_1
Xoutput321 net320 VSS VSS VDD VDD out_flat[37] sky130_fd_sc_hd__clkdlybuf4s50_1
Xoutput322 net321 VSS VSS VDD VDD out_flat[38] sky130_fd_sc_hd__clkdlybuf4s50_1
Xoutput323 net322 VSS VSS VDD VDD out_flat[39] sky130_fd_sc_hd__clkdlybuf4s50_1
Xoutput324 net323 VSS VSS VDD VDD out_flat[3] sky130_fd_sc_hd__clkdlybuf4s50_1
Xoutput325 net324 VSS VSS VDD VDD out_flat[40] sky130_fd_sc_hd__clkdlybuf4s50_1
Xoutput326 net325 VSS VSS VDD VDD out_flat[41] sky130_fd_sc_hd__clkdlybuf4s50_1
Xoutput327 net326 VSS VSS VDD VDD out_flat[42] sky130_fd_sc_hd__clkdlybuf4s50_1
Xoutput328 net327 VSS VSS VDD VDD out_flat[43] sky130_fd_sc_hd__clkdlybuf4s50_1
Xoutput329 net328 VSS VSS VDD VDD out_flat[44] sky130_fd_sc_hd__clkdlybuf4s50_1
Xoutput330 net329 VSS VSS VDD VDD out_flat[45] sky130_fd_sc_hd__clkdlybuf4s50_1
Xoutput331 net330 VSS VSS VDD VDD out_flat[46] sky130_fd_sc_hd__clkdlybuf4s50_1
Xoutput332 net331 VSS VSS VDD VDD out_flat[47] sky130_fd_sc_hd__clkdlybuf4s50_1
Xoutput333 net234 VSS VSS VDD VDD out_flat[48] sky130_fd_sc_hd__clkdlybuf4s50_1
Xoutput334 net235 VSS VSS VDD VDD out_flat[49] sky130_fd_sc_hd__clkdlybuf4s50_1
Xoutput335 net334 VSS VSS VDD VDD out_flat[4] sky130_fd_sc_hd__clkdlybuf4s50_1
Xoutput336 net236 VSS VSS VDD VDD out_flat[50] sky130_fd_sc_hd__clkdlybuf4s50_1
Xoutput337 net237 VSS VSS VDD VDD out_flat[51] sky130_fd_sc_hd__clkdlybuf4s50_1
Xoutput338 net239 VSS VSS VDD VDD out_flat[52] sky130_fd_sc_hd__clkdlybuf4s50_1
Xoutput339 net240 VSS VSS VDD VDD out_flat[53] sky130_fd_sc_hd__clkdlybuf4s50_1
Xoutput340 net241 VSS VSS VDD VDD out_flat[54] sky130_fd_sc_hd__clkdlybuf4s50_1
Xoutput341 net242 VSS VSS VDD VDD out_flat[55] sky130_fd_sc_hd__clkdlybuf4s50_1
Xoutput342 net243 VSS VSS VDD VDD out_flat[56] sky130_fd_sc_hd__clkdlybuf4s50_1
Xoutput343 net244 VSS VSS VDD VDD out_flat[57] sky130_fd_sc_hd__clkdlybuf4s50_1
Xoutput344 net245 VSS VSS VDD VDD out_flat[58] sky130_fd_sc_hd__clkdlybuf4s50_1
Xoutput345 net246 VSS VSS VDD VDD out_flat[59] sky130_fd_sc_hd__clkdlybuf4s50_1
Xoutput346 net345 VSS VSS VDD VDD out_flat[5] sky130_fd_sc_hd__clkdlybuf4s50_1
Xoutput347 net247 VSS VSS VDD VDD out_flat[60] sky130_fd_sc_hd__clkdlybuf4s50_1
Xoutput348 net248 VSS VSS VDD VDD out_flat[61] sky130_fd_sc_hd__clkdlybuf4s50_1
Xoutput349 net251 VSS VSS VDD VDD out_flat[62] sky130_fd_sc_hd__clkdlybuf4s50_1
Xoutput350 net251 VSS VSS VDD VDD out_flat[63] sky130_fd_sc_hd__clkdlybuf4s50_1
Xoutput351 net350 VSS VSS VDD VDD out_flat[64] sky130_fd_sc_hd__clkdlybuf4s50_1
Xoutput352 net351 VSS VSS VDD VDD out_flat[65] sky130_fd_sc_hd__clkdlybuf4s50_1
Xoutput353 net352 VSS VSS VDD VDD out_flat[66] sky130_fd_sc_hd__clkdlybuf4s50_1
Xoutput354 net353 VSS VSS VDD VDD out_flat[67] sky130_fd_sc_hd__clkdlybuf4s50_1
Xoutput355 net354 VSS VSS VDD VDD out_flat[68] sky130_fd_sc_hd__clkdlybuf4s50_1
Xoutput356 net355 VSS VSS VDD VDD out_flat[69] sky130_fd_sc_hd__clkdlybuf4s50_1
Xoutput357 net356 VSS VSS VDD VDD out_flat[6] sky130_fd_sc_hd__clkdlybuf4s50_1
Xoutput358 net357 VSS VSS VDD VDD out_flat[70] sky130_fd_sc_hd__clkdlybuf4s50_1
Xoutput359 net358 VSS VSS VDD VDD out_flat[71] sky130_fd_sc_hd__clkdlybuf4s50_1
Xoutput360 net359 VSS VSS VDD VDD out_flat[72] sky130_fd_sc_hd__clkdlybuf4s50_1
Xoutput361 net360 VSS VSS VDD VDD out_flat[73] sky130_fd_sc_hd__clkdlybuf4s50_1
Xoutput362 net361 VSS VSS VDD VDD out_flat[74] sky130_fd_sc_hd__clkdlybuf4s50_1
Xoutput363 net362 VSS VSS VDD VDD out_flat[75] sky130_fd_sc_hd__clkdlybuf4s50_1
Xoutput364 net363 VSS VSS VDD VDD out_flat[76] sky130_fd_sc_hd__clkdlybuf4s50_1
Xoutput365 net364 VSS VSS VDD VDD out_flat[77] sky130_fd_sc_hd__clkdlybuf4s50_1
Xoutput366 net365 VSS VSS VDD VDD out_flat[78] sky130_fd_sc_hd__clkdlybuf4s50_1
Xoutput367 net366 VSS VSS VDD VDD out_flat[79] sky130_fd_sc_hd__clkdlybuf4s50_1
Xoutput368 net367 VSS VSS VDD VDD out_flat[7] sky130_fd_sc_hd__clkdlybuf4s50_1
Xoutput369 net368 VSS VSS VDD VDD out_flat[80] sky130_fd_sc_hd__clkdlybuf4s50_1
Xoutput370 net369 VSS VSS VDD VDD out_flat[81] sky130_fd_sc_hd__clkdlybuf4s50_1
Xoutput371 net370 VSS VSS VDD VDD out_flat[82] sky130_fd_sc_hd__clkdlybuf4s50_1
Xoutput372 net371 VSS VSS VDD VDD out_flat[83] sky130_fd_sc_hd__clkdlybuf4s50_1
Xoutput373 net372 VSS VSS VDD VDD out_flat[84] sky130_fd_sc_hd__clkdlybuf4s50_1
Xoutput374 net373 VSS VSS VDD VDD out_flat[85] sky130_fd_sc_hd__clkdlybuf4s50_1
Xoutput375 net374 VSS VSS VDD VDD out_flat[86] sky130_fd_sc_hd__clkdlybuf4s50_1
Xoutput376 net375 VSS VSS VDD VDD out_flat[87] sky130_fd_sc_hd__clkdlybuf4s50_1
Xoutput377 net376 VSS VSS VDD VDD out_flat[88] sky130_fd_sc_hd__clkdlybuf4s50_1
Xoutput378 net377 VSS VSS VDD VDD out_flat[89] sky130_fd_sc_hd__clkdlybuf4s50_1
Xoutput379 net378 VSS VSS VDD VDD out_flat[8] sky130_fd_sc_hd__clkdlybuf4s50_1
Xoutput380 net379 VSS VSS VDD VDD out_flat[90] sky130_fd_sc_hd__clkdlybuf4s50_1
Xoutput381 net380 VSS VSS VDD VDD out_flat[91] sky130_fd_sc_hd__clkdlybuf4s50_1
Xoutput382 net381 VSS VSS VDD VDD out_flat[92] sky130_fd_sc_hd__clkdlybuf4s50_1
Xoutput383 net382 VSS VSS VDD VDD out_flat[93] sky130_fd_sc_hd__clkdlybuf4s50_1
Xoutput384 net383 VSS VSS VDD VDD out_flat[94] sky130_fd_sc_hd__clkdlybuf4s50_1
Xoutput385 net384 VSS VSS VDD VDD out_flat[95] sky130_fd_sc_hd__clkdlybuf4s50_1
Xoutput386 net385 VSS VSS VDD VDD out_flat[9] sky130_fd_sc_hd__clkdlybuf4s50_1
Xoutput387 net386 VSS VSS VDD VDD out_valid sky130_fd_sc_hd__clkdlybuf4s50_1
Xplace461 net465 VSS VSS VDD VDD net460 sky130_fd_sc_hd__buf_4
Xplace413 _01979_ VSS VSS VDD VDD net412 sky130_fd_sc_hd__buf_4
Xplace412 _01791_ VSS VSS VDD VDD net411 sky130_fd_sc_hd__buf_4
Xplace415 _03203_ VSS VSS VDD VDD net414 sky130_fd_sc_hd__buf_4
Xplace416 _03249_ VSS VSS VDD VDD net415 sky130_fd_sc_hd__buf_4
Xplace414 _03219_ VSS VSS VDD VDD net413 sky130_fd_sc_hd__buf_4
Xplace427 _00934_ VSS VSS VDD VDD net426 sky130_fd_sc_hd__buf_4
Xplace431 _00044_ VSS VSS VDD VDD net430 sky130_fd_sc_hd__buf_4
Xplace432 net432 VSS VSS VDD VDD net431 sky130_fd_sc_hd__buf_4
Xplace434 stage3_in_r\[29\] VSS VSS VDD VDD net433 sky130_fd_sc_hd__buf_4
Xplace437 stage3_in_r\[26\] VSS VSS VDD VDD net436 sky130_fd_sc_hd__buf_4
Xplace438 stage3_in_r\[25\] VSS VSS VDD VDD net437 sky130_fd_sc_hd__buf_4
Xplace439 stage3_in_r\[24\] VSS VSS VDD VDD net438 sky130_fd_sc_hd__buf_4
Xplace440 stage3_in_r\[23\] VSS VSS VDD VDD net439 sky130_fd_sc_hd__buf_4
Xplace442 stage3_in_r\[21\] VSS VSS VDD VDD net441 sky130_fd_sc_hd__buf_4
Xplace449 stage3_in_r\[75\] VSS VSS VDD VDD net448 sky130_fd_sc_hd__buf_4
Xclkbuf_leaf_5_clk clknet_3_0__leaf_clk VSS VSS VDD VDD clknet_leaf_5_clk
+ sky130_fd_sc_hd__clkbuf_16
Xclkbuf_leaf_3_clk clknet_3_0__leaf_clk VSS VSS VDD VDD clknet_leaf_3_clk
+ sky130_fd_sc_hd__clkbuf_16
Xclkbuf_leaf_0_clk clknet_3_0__leaf_clk VSS VSS VDD VDD clknet_leaf_0_clk
+ sky130_fd_sc_hd__clkbuf_16
Xclkbuf_leaf_2_clk clknet_3_1__leaf_clk VSS VSS VDD VDD clknet_leaf_2_clk
+ sky130_fd_sc_hd__clkbuf_16
Xclkbuf_leaf_1_clk clknet_3_1__leaf_clk VSS VSS VDD VDD clknet_leaf_1_clk
+ sky130_fd_sc_hd__clkbuf_16
Xclkbuf_leaf_4_clk clknet_3_0__leaf_clk VSS VSS VDD VDD clknet_leaf_4_clk
+ sky130_fd_sc_hd__clkbuf_16
Xclkbuf_leaf_6_clk clknet_3_0__leaf_clk VSS VSS VDD VDD clknet_leaf_6_clk
+ sky130_fd_sc_hd__clkbuf_16
Xplace417 _01749_ VSS VSS VDD VDD net416 sky130_fd_sc_hd__buf_4
Xplace418 _01743_ VSS VSS VDD VDD net417 sky130_fd_sc_hd__buf_4
Xplace419 _03243_ VSS VSS VDD VDD net418 sky130_fd_sc_hd__buf_4
Xplace420 _03126_ VSS VSS VDD VDD net419 sky130_fd_sc_hd__buf_4
Xplace421 _03087_ VSS VSS VDD VDD net420 sky130_fd_sc_hd__buf_4
Xplace422 _01724_ VSS VSS VDD VDD net421 sky130_fd_sc_hd__buf_4
Xplace423 _01687_ VSS VSS VDD VDD net422 sky130_fd_sc_hd__buf_4
Xplace424 _01669_ VSS VSS VDD VDD net423 sky130_fd_sc_hd__buf_4
Xplace425 stage1_out\[190\] VSS VSS VDD VDD net424 sky130_fd_sc_hd__buf_4
Xplace426 _02911_ VSS VSS VDD VDD net425 sky130_fd_sc_hd__buf_4
Xplace428 _03425_ VSS VSS VDD VDD net427 sky130_fd_sc_hd__buf_4
Xplace429 _00309_ VSS VSS VDD VDD net428 sky130_fd_sc_hd__buf_4
Xplace430 _00143_ VSS VSS VDD VDD net429 sky130_fd_sc_hd__buf_4
Xplace433 stage3_in_r\[30\] VSS VSS VDD VDD net432 sky130_fd_sc_hd__buf_4
Xplace435 stage3_in_r\[28\] VSS VSS VDD VDD net434 sky130_fd_sc_hd__buf_4
Xplace436 stage3_in_r\[27\] VSS VSS VDD VDD net435 sky130_fd_sc_hd__buf_4
Xplace441 stage3_in_r\[22\] VSS VSS VDD VDD net440 sky130_fd_sc_hd__buf_4
Xplace443 stage3_in_r\[20\] VSS VSS VDD VDD net442 sky130_fd_sc_hd__buf_4
Xplace444 stage3_in_r\[19\] VSS VSS VDD VDD net443 sky130_fd_sc_hd__buf_4
Xplace445 stage3_in_r\[18\] VSS VSS VDD VDD net444 sky130_fd_sc_hd__buf_4
Xplace446 stage3_in_r\[16\] VSS VSS VDD VDD net445 sky130_fd_sc_hd__buf_4
Xplace447 stage3_in_r\[78\] VSS VSS VDD VDD net446 sky130_fd_sc_hd__buf_4
Xplace448 stage3_in_r\[78\] VSS VSS VDD VDD net447 sky130_fd_sc_hd__buf_4
Xplace450 stage3_in_r\[74\] VSS VSS VDD VDD net449 sky130_fd_sc_hd__buf_4
Xplace451 stage3_in_r\[73\] VSS VSS VDD VDD net450 sky130_fd_sc_hd__buf_4
Xplace452 stage3_in_r\[70\] VSS VSS VDD VDD net451 sky130_fd_sc_hd__buf_4
Xplace453 stage3_in_r\[69\] VSS VSS VDD VDD net452 sky130_fd_sc_hd__buf_4
Xplace454 stage3_in_r\[68\] VSS VSS VDD VDD net453 sky130_fd_sc_hd__buf_4
Xplace455 stage3_in_r\[67\] VSS VSS VDD VDD net454 sky130_fd_sc_hd__buf_4
Xplace456 stage3_in_r\[66\] VSS VSS VDD VDD net455 sky130_fd_sc_hd__buf_4
Xplace457 stage3_in_r\[65\] VSS VSS VDD VDD net456 sky130_fd_sc_hd__buf_4
Xplace458 stage3_in_r\[64\] VSS VSS VDD VDD net457 sky130_fd_sc_hd__buf_4
Xplace459 stage3_in_r\[144\] VSS VSS VDD VDD net458 sky130_fd_sc_hd__buf_4
Xplace460 stage3_in_r\[15\] VSS VSS VDD VDD net459 sky130_fd_sc_hd__buf_4
Xplace462 net463 VSS VSS VDD VDD net461 sky130_fd_sc_hd__buf_4
Xplace463 net463 VSS VSS VDD VDD net462 sky130_fd_sc_hd__buf_4
Xplace464 net465 VSS VSS VDD VDD net463 sky130_fd_sc_hd__buf_4
Xplace465 net465 VSS VSS VDD VDD net464 sky130_fd_sc_hd__buf_4
Xplace466 net466 VSS VSS VDD VDD net465 sky130_fd_sc_hd__buf_4
Xplace467 net161 VSS VSS VDD VDD net466 sky130_fd_sc_hd__buf_4
Xplace468 net468 VSS VSS VDD VDD net467 sky130_fd_sc_hd__buf_4
Xplace469 net161 VSS VSS VDD VDD net468 sky130_fd_sc_hd__buf_4
Xclkbuf_leaf_7_clk clknet_3_1__leaf_clk VSS VSS VDD VDD clknet_leaf_7_clk
+ sky130_fd_sc_hd__clkbuf_16
Xclkbuf_leaf_8_clk clknet_3_1__leaf_clk VSS VSS VDD VDD clknet_leaf_8_clk
+ sky130_fd_sc_hd__clkbuf_16
Xclkbuf_leaf_9_clk clknet_3_6__leaf_clk VSS VSS VDD VDD clknet_leaf_9_clk
+ sky130_fd_sc_hd__clkbuf_16
Xclkbuf_leaf_10_clk clknet_3_6__leaf_clk VSS VSS VDD VDD clknet_leaf_10_clk
+ sky130_fd_sc_hd__clkbuf_16
Xclkbuf_leaf_11_clk clknet_3_3__leaf_clk VSS VSS VDD VDD clknet_leaf_11_clk
+ sky130_fd_sc_hd__clkbuf_16
Xclkbuf_leaf_12_clk clknet_3_3__leaf_clk VSS VSS VDD VDD clknet_leaf_12_clk
+ sky130_fd_sc_hd__clkbuf_16
Xclkbuf_leaf_13_clk clknet_3_2__leaf_clk VSS VSS VDD VDD clknet_leaf_13_clk
+ sky130_fd_sc_hd__clkbuf_16
Xclkbuf_leaf_14_clk clknet_3_0__leaf_clk VSS VSS VDD VDD clknet_leaf_14_clk
+ sky130_fd_sc_hd__clkbuf_16
Xclkbuf_leaf_15_clk clknet_3_0__leaf_clk VSS VSS VDD VDD clknet_leaf_15_clk
+ sky130_fd_sc_hd__clkbuf_16
Xclkbuf_leaf_16_clk clknet_3_2__leaf_clk VSS VSS VDD VDD clknet_leaf_16_clk
+ sky130_fd_sc_hd__clkbuf_16
Xclkbuf_leaf_17_clk clknet_3_2__leaf_clk VSS VSS VDD VDD clknet_leaf_17_clk
+ sky130_fd_sc_hd__clkbuf_16
Xclkbuf_leaf_18_clk clknet_3_2__leaf_clk VSS VSS VDD VDD clknet_leaf_18_clk
+ sky130_fd_sc_hd__clkbuf_16
Xclkbuf_leaf_19_clk clknet_3_2__leaf_clk VSS VSS VDD VDD clknet_leaf_19_clk
+ sky130_fd_sc_hd__clkbuf_16
Xclkbuf_leaf_20_clk clknet_3_2__leaf_clk VSS VSS VDD VDD clknet_leaf_20_clk
+ sky130_fd_sc_hd__clkbuf_16
Xclkbuf_leaf_21_clk clknet_3_2__leaf_clk VSS VSS VDD VDD clknet_leaf_21_clk
+ sky130_fd_sc_hd__clkbuf_16
Xclkbuf_leaf_22_clk clknet_3_2__leaf_clk VSS VSS VDD VDD clknet_leaf_22_clk
+ sky130_fd_sc_hd__clkbuf_16
Xclkbuf_leaf_23_clk clknet_3_2__leaf_clk VSS VSS VDD VDD clknet_leaf_23_clk
+ sky130_fd_sc_hd__clkbuf_16
Xclkbuf_leaf_24_clk clknet_3_2__leaf_clk VSS VSS VDD VDD clknet_leaf_24_clk
+ sky130_fd_sc_hd__clkbuf_16
Xclkbuf_leaf_25_clk clknet_3_3__leaf_clk VSS VSS VDD VDD clknet_leaf_25_clk
+ sky130_fd_sc_hd__clkbuf_16
Xclkbuf_leaf_26_clk clknet_3_3__leaf_clk VSS VSS VDD VDD clknet_leaf_26_clk
+ sky130_fd_sc_hd__clkbuf_16
Xclkbuf_leaf_27_clk clknet_3_3__leaf_clk VSS VSS VDD VDD clknet_leaf_27_clk
+ sky130_fd_sc_hd__clkbuf_16
Xclkbuf_leaf_28_clk clknet_3_3__leaf_clk VSS VSS VDD VDD clknet_leaf_28_clk
+ sky130_fd_sc_hd__clkbuf_16
Xclkbuf_leaf_29_clk clknet_3_3__leaf_clk VSS VSS VDD VDD clknet_leaf_29_clk
+ sky130_fd_sc_hd__clkbuf_16
Xclkbuf_leaf_30_clk clknet_3_3__leaf_clk VSS VSS VDD VDD clknet_leaf_30_clk
+ sky130_fd_sc_hd__clkbuf_16
Xclkbuf_leaf_31_clk clknet_3_3__leaf_clk VSS VSS VDD VDD clknet_leaf_31_clk
+ sky130_fd_sc_hd__clkbuf_16
Xclkbuf_leaf_32_clk clknet_3_7__leaf_clk VSS VSS VDD VDD clknet_leaf_32_clk
+ sky130_fd_sc_hd__clkbuf_16
Xclkbuf_leaf_33_clk clknet_3_7__leaf_clk VSS VSS VDD VDD clknet_leaf_33_clk
+ sky130_fd_sc_hd__clkbuf_16
Xclkbuf_leaf_34_clk clknet_3_7__leaf_clk VSS VSS VDD VDD clknet_leaf_34_clk
+ sky130_fd_sc_hd__clkbuf_16
Xclkbuf_leaf_35_clk clknet_3_7__leaf_clk VSS VSS VDD VDD clknet_leaf_35_clk
+ sky130_fd_sc_hd__clkbuf_16
Xclkbuf_leaf_36_clk clknet_3_6__leaf_clk VSS VSS VDD VDD clknet_leaf_36_clk
+ sky130_fd_sc_hd__clkbuf_16
Xclkbuf_leaf_37_clk clknet_3_6__leaf_clk VSS VSS VDD VDD clknet_leaf_37_clk
+ sky130_fd_sc_hd__clkbuf_16
Xclkbuf_leaf_38_clk clknet_3_5__leaf_clk VSS VSS VDD VDD clknet_leaf_38_clk
+ sky130_fd_sc_hd__clkbuf_16
Xclkbuf_leaf_39_clk clknet_3_5__leaf_clk VSS VSS VDD VDD clknet_leaf_39_clk
+ sky130_fd_sc_hd__clkbuf_16
Xclkbuf_leaf_40_clk clknet_3_5__leaf_clk VSS VSS VDD VDD clknet_leaf_40_clk
+ sky130_fd_sc_hd__clkbuf_16
Xclkbuf_leaf_41_clk clknet_3_5__leaf_clk VSS VSS VDD VDD clknet_leaf_41_clk
+ sky130_fd_sc_hd__clkbuf_16
Xclkbuf_leaf_42_clk clknet_3_5__leaf_clk VSS VSS VDD VDD clknet_leaf_42_clk
+ sky130_fd_sc_hd__clkbuf_16
Xclkbuf_leaf_43_clk clknet_3_5__leaf_clk VSS VSS VDD VDD clknet_leaf_43_clk
+ sky130_fd_sc_hd__clkbuf_16
Xclkbuf_leaf_44_clk clknet_3_5__leaf_clk VSS VSS VDD VDD clknet_leaf_44_clk
+ sky130_fd_sc_hd__clkbuf_16
Xclkbuf_leaf_45_clk clknet_3_5__leaf_clk VSS VSS VDD VDD clknet_leaf_45_clk
+ sky130_fd_sc_hd__clkbuf_16
Xclkbuf_leaf_46_clk clknet_3_4__leaf_clk VSS VSS VDD VDD clknet_leaf_46_clk
+ sky130_fd_sc_hd__clkbuf_16
Xclkbuf_leaf_47_clk clknet_3_4__leaf_clk VSS VSS VDD VDD clknet_leaf_47_clk
+ sky130_fd_sc_hd__clkbuf_16
Xclkbuf_leaf_48_clk clknet_3_4__leaf_clk VSS VSS VDD VDD clknet_leaf_48_clk
+ sky130_fd_sc_hd__clkbuf_16
Xclkbuf_leaf_49_clk clknet_3_4__leaf_clk VSS VSS VDD VDD clknet_leaf_49_clk
+ sky130_fd_sc_hd__clkbuf_16
Xclkbuf_leaf_50_clk clknet_3_6__leaf_clk VSS VSS VDD VDD clknet_leaf_50_clk
+ sky130_fd_sc_hd__clkbuf_16
Xclkbuf_leaf_51_clk clknet_3_4__leaf_clk VSS VSS VDD VDD clknet_leaf_51_clk
+ sky130_fd_sc_hd__clkbuf_16
Xclkbuf_leaf_52_clk clknet_3_4__leaf_clk VSS VSS VDD VDD clknet_leaf_52_clk
+ sky130_fd_sc_hd__clkbuf_16
Xclkbuf_leaf_53_clk clknet_3_1__leaf_clk VSS VSS VDD VDD clknet_leaf_53_clk
+ sky130_fd_sc_hd__clkbuf_16
Xclkbuf_leaf_54_clk clknet_3_1__leaf_clk VSS VSS VDD VDD clknet_leaf_54_clk
+ sky130_fd_sc_hd__clkbuf_16
Xclkbuf_leaf_55_clk clknet_3_1__leaf_clk VSS VSS VDD VDD clknet_leaf_55_clk
+ sky130_fd_sc_hd__clkbuf_16
Xclkbuf_leaf_56_clk clknet_3_0__leaf_clk VSS VSS VDD VDD clknet_leaf_56_clk
+ sky130_fd_sc_hd__clkbuf_16
Xclkbuf_leaf_57_clk clknet_3_0__leaf_clk VSS VSS VDD VDD clknet_leaf_57_clk
+ sky130_fd_sc_hd__clkbuf_16
Xclkbuf_leaf_58_clk clknet_3_0__leaf_clk VSS VSS VDD VDD clknet_leaf_58_clk
+ sky130_fd_sc_hd__clkbuf_16
Xclkbuf_0_clk clk VSS VSS VDD VDD clknet_0_clk sky130_fd_sc_hd__clkbuf_16
Xclkbuf_3_0__f_clk clknet_0_clk VSS VSS VDD VDD clknet_3_0__leaf_clk
+ sky130_fd_sc_hd__clkbuf_16
Xclkbuf_3_1__f_clk clknet_0_clk VSS VSS VDD VDD clknet_3_1__leaf_clk
+ sky130_fd_sc_hd__clkbuf_16
Xclkbuf_3_2__f_clk clknet_0_clk VSS VSS VDD VDD clknet_3_2__leaf_clk
+ sky130_fd_sc_hd__clkbuf_16
Xclkbuf_3_3__f_clk clknet_0_clk VSS VSS VDD VDD clknet_3_3__leaf_clk
+ sky130_fd_sc_hd__clkbuf_16
Xclkbuf_3_4__f_clk clknet_0_clk VSS VSS VDD VDD clknet_3_4__leaf_clk
+ sky130_fd_sc_hd__clkbuf_16
Xclkbuf_3_5__f_clk clknet_0_clk VSS VSS VDD VDD clknet_3_5__leaf_clk
+ sky130_fd_sc_hd__clkbuf_16
Xclkbuf_3_6__f_clk clknet_0_clk VSS VSS VDD VDD clknet_3_6__leaf_clk
+ sky130_fd_sc_hd__clkbuf_16
Xclkbuf_3_7__f_clk clknet_0_clk VSS VSS VDD VDD clknet_3_7__leaf_clk
+ sky130_fd_sc_hd__clkbuf_16
Xclkload0 clknet_3_1__leaf_clk VSS VSS VDD VDD _unconnected_32
+ sky130_fd_sc_hd__clkinv_8
Xclkload1 clknet_3_3__leaf_clk VSS VSS VDD VDD _unconnected_33
+ sky130_fd_sc_hd__clkbuf_16
Xclkload2 clknet_3_4__leaf_clk VSS VSS VDD VDD _unconnected_34
+ sky130_fd_sc_hd__inv_16
Xclkload3 clknet_3_5__leaf_clk VSS VSS VDD VDD _unconnected_35
+ sky130_fd_sc_hd__inv_6
Xclkload4 clknet_3_6__leaf_clk VSS VSS VDD VDD _unconnected_36
+ sky130_fd_sc_hd__clkinv_16
Xclkload5 clknet_3_7__leaf_clk VSS VSS VDD VDD _unconnected_37
+ sky130_fd_sc_hd__clkinv_16
Xclkload6 clknet_leaf_0_clk VSS VSS VDD VDD _unconnected_38
+ sky130_fd_sc_hd__clkinvlp_4
Xclkload7 clknet_leaf_3_clk VSS VSS VDD VDD _unconnected_39
+ sky130_fd_sc_hd__clkbuf_8
Xclkload8 clknet_leaf_4_clk VSS VSS VDD VDD _unconnected_40
+ sky130_fd_sc_hd__bufinv_16
Xclkload9 clknet_leaf_6_clk VSS VSS VDD VDD _unconnected_41
+ sky130_fd_sc_hd__clkinvlp_4
Xclkload10 clknet_leaf_14_clk VSS VSS VDD VDD _unconnected_42
+ sky130_fd_sc_hd__clkinv_2
Xclkload11 clknet_leaf_15_clk VSS VSS VDD VDD _unconnected_43
+ sky130_fd_sc_hd__clkinv_2
Xclkload12 clknet_leaf_57_clk VSS VSS VDD VDD _unconnected_44
+ sky130_fd_sc_hd__clkbuf_8
Xclkload13 clknet_leaf_58_clk VSS VSS VDD VDD _unconnected_45
+ sky130_fd_sc_hd__clkinvlp_4
Xclkload14 clknet_leaf_1_clk VSS VSS VDD VDD _unconnected_46
+ sky130_fd_sc_hd__clkbuf_1
Xclkload15 clknet_leaf_2_clk VSS VSS VDD VDD _unconnected_47
+ sky130_fd_sc_hd__bufinv_16
Xclkload16 clknet_leaf_7_clk VSS VSS VDD VDD _unconnected_48
+ sky130_fd_sc_hd__bufinv_16
Xclkload17 clknet_leaf_8_clk VSS VSS VDD VDD _unconnected_49
+ sky130_fd_sc_hd__bufinv_16
Xclkload18 clknet_leaf_53_clk VSS VSS VDD VDD _unconnected_50
+ sky130_fd_sc_hd__bufinv_16
Xclkload19 clknet_leaf_55_clk VSS VSS VDD VDD _unconnected_51
+ sky130_fd_sc_hd__clkbuf_1
Xclkload20 clknet_leaf_13_clk VSS VSS VDD VDD _unconnected_52
+ sky130_fd_sc_hd__clkbuf_8
Xclkload21 clknet_leaf_16_clk VSS VSS VDD VDD _unconnected_53
+ sky130_fd_sc_hd__clkbuf_8
Xclkload22 clknet_leaf_17_clk VSS VSS VDD VDD _unconnected_54
+ sky130_fd_sc_hd__clkbuf_8
Xclkload23 clknet_leaf_18_clk VSS VSS VDD VDD _unconnected_55
+ sky130_fd_sc_hd__clkinvlp_4
Xclkload24 clknet_leaf_20_clk VSS VSS VDD VDD _unconnected_56
+ sky130_fd_sc_hd__clkbuf_8
Xclkload25 clknet_leaf_21_clk VSS VSS VDD VDD _unconnected_57
+ sky130_fd_sc_hd__clkbuf_1
Xclkload26 clknet_leaf_22_clk VSS VSS VDD VDD _unconnected_58
+ sky130_fd_sc_hd__clkbuf_1
Xclkload27 clknet_leaf_24_clk VSS VSS VDD VDD _unconnected_59
+ sky130_fd_sc_hd__bufinv_16
Xclkload28 clknet_leaf_11_clk VSS VSS VDD VDD _unconnected_60
+ sky130_fd_sc_hd__clkbuf_8
Xclkload29 clknet_leaf_12_clk VSS VSS VDD VDD _unconnected_61
+ sky130_fd_sc_hd__clkbuf_8
Xclkload30 clknet_leaf_25_clk VSS VSS VDD VDD _unconnected_62
+ sky130_fd_sc_hd__bufinv_16
Xclkload31 clknet_leaf_26_clk VSS VSS VDD VDD _unconnected_63
+ sky130_fd_sc_hd__clkbuf_1
Xclkload32 clknet_leaf_27_clk VSS VSS VDD VDD _unconnected_64
+ sky130_fd_sc_hd__clkbuf_8
Xclkload33 clknet_leaf_28_clk VSS VSS VDD VDD _unconnected_65
+ sky130_fd_sc_hd__clkinvlp_4
Xclkload34 clknet_leaf_29_clk VSS VSS VDD VDD _unconnected_66
+ sky130_fd_sc_hd__inv_6
Xclkload35 clknet_leaf_31_clk VSS VSS VDD VDD _unconnected_67
+ sky130_fd_sc_hd__inv_6
Xclkload36 clknet_leaf_46_clk VSS VSS VDD VDD _unconnected_68
+ sky130_fd_sc_hd__clkbuf_1
Xclkload37 clknet_leaf_47_clk VSS VSS VDD VDD _unconnected_69
+ sky130_fd_sc_hd__clkbuf_1
Xclkload38 clknet_leaf_48_clk VSS VSS VDD VDD _unconnected_70
+ sky130_fd_sc_hd__clkinv_2
Xclkload39 clknet_leaf_49_clk VSS VSS VDD VDD _unconnected_71
+ sky130_fd_sc_hd__inv_6
Xclkload40 clknet_leaf_52_clk VSS VSS VDD VDD _unconnected_72
+ sky130_fd_sc_hd__clkinv_2
Xclkload41 clknet_leaf_38_clk VSS VSS VDD VDD _unconnected_73
+ sky130_fd_sc_hd__clkbuf_8
Xclkload42 clknet_leaf_39_clk VSS VSS VDD VDD _unconnected_74
+ sky130_fd_sc_hd__inv_6
Xclkload43 clknet_leaf_40_clk VSS VSS VDD VDD _unconnected_75
+ sky130_fd_sc_hd__clkinvlp_4
Xclkload44 clknet_leaf_41_clk VSS VSS VDD VDD _unconnected_76
+ sky130_fd_sc_hd__clkbuf_8
Xclkload45 clknet_leaf_42_clk VSS VSS VDD VDD _unconnected_77
+ sky130_fd_sc_hd__clkbuf_1
Xclkload46 clknet_leaf_44_clk VSS VSS VDD VDD _unconnected_78
+ sky130_fd_sc_hd__bufinv_16
Xclkload47 clknet_leaf_45_clk VSS VSS VDD VDD _unconnected_79
+ sky130_fd_sc_hd__clkinvlp_4
Xclkload48 clknet_leaf_10_clk VSS VSS VDD VDD _unconnected_80
+ sky130_fd_sc_hd__clkinv_2
Xclkload49 clknet_leaf_36_clk VSS VSS VDD VDD _unconnected_81
+ sky130_fd_sc_hd__clkinvlp_4
Xclkload50 clknet_leaf_37_clk VSS VSS VDD VDD _unconnected_82
+ sky130_fd_sc_hd__clkinv_4
Xclkload51 clknet_leaf_50_clk VSS VSS VDD VDD _unconnected_83
+ sky130_fd_sc_hd__inv_6
Xclkload52 clknet_leaf_32_clk VSS VSS VDD VDD _unconnected_84
+ sky130_fd_sc_hd__bufinv_16
Xclkload53 clknet_leaf_33_clk VSS VSS VDD VDD _unconnected_85
+ sky130_fd_sc_hd__clkbuf_1
Xclkload54 clknet_leaf_35_clk VSS VSS VDD VDD _unconnected_86
+ sky130_fd_sc_hd__clkbuf_1
Xrebuffer470 _04444_ VSS VSS VDD VDD net469 sky130_fd_sc_hd__buf_4
Xrebuffer471 _04420_ VSS VSS VDD VDD net470 sky130_fd_sc_hd__buf_4
XANTENNA_1 stage1_out\[191\] VSS VSS VDD VDD sky130_fd_sc_hd__diode_2
XANTENNA_2 stage2_out\[71\] VSS VSS VDD VDD sky130_fd_sc_hd__diode_2
.ENDS fft_8point_top
